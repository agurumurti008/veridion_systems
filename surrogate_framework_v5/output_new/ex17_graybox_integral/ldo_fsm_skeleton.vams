// Auto-generated Verilog-A FSM — LDO
// Generated by surrogate_framework FSMCodeGenerator

`include "disciplines.vams"
`include "constants.vams"

module ldo_fsm_model(
    VPWR, GND, floop_out, floop_in, EN_LDO, EN_UVLO_1V2, VPWR_SEL, PAD_VDD1V2_SEL, UVLO_GD_OR_OVERRIDE_MPOS, HIGH_POWER_MODE, SCAN_MODE_VSUPPLY, EN_SCAN_MODE_MPOS, FS_V_SUPPLY_TO_MOST_POS, SREF_ADD_LDO1V2_LOAD_MPOS, SREF_EN_ISENSE_LDO1V2_MPOS, SREF_LDO_ISNS_DIS_MPOS, IBIAS_SNK_25nA_0, IBIAS_SNK_25nA_1, IBIAS_SNK_25nA_2, ICONST_75A, VFB, VREF, AVSS, PBKG, FUN_DC, ISO, MOST_POS, VDD_1V2, VDD_1V2_EXT, V_SUPPLY
);

    input floop_in, IBIAS_SNK_25nA_0, IBIAS_SNK_25nA_1, IBIAS_SNK_25nA_2, ICONST_75A, VFB, VREF;
    output floop_out, EN_UVLO_1V2;
    inout VPWR, GND, AVSS, PBKG, FUN_DC, ISO, MOST_POS, VDD_1V2, VDD_1V2_EXT, V_SUPPLY;
    electrical VPWR, GND, floop_out, floop_in, EN_UVLO_1V2, IBIAS_SNK_25nA_0, IBIAS_SNK_25nA_1, IBIAS_SNK_25nA_2, ICONST_75A, VFB, VREF, AVSS, PBKG, FUN_DC, ISO, MOST_POS, VDD_1V2, VDD_1V2_EXT, V_SUPPLY;

    // Corner/meta parameters (equation inputs with
    // no physical pin — override per simulated corner)
    parameter real meta_corner = -1.8102e-09;
    parameter real meta_temp = -4.29365;
    parameter real meta_vsup_max = 5.04993;

    // Supply-sensitive logic pins (mixed-signal
    // boundary via attribute annotation, no V()
    // threshold needed — see _va_guard).
    input (* integer supplySensitivity = "V_SUPPLY"; integer groundSensitivity = "GND"; *) EN_LDO;
    logic EN_LDO;
    input (* integer supplySensitivity = "V_SUPPLY"; integer groundSensitivity = "GND"; *) VPWR_SEL;
    logic VPWR_SEL;
    input (* integer supplySensitivity = "V_SUPPLY"; integer groundSensitivity = "GND"; *) PAD_VDD1V2_SEL;
    logic PAD_VDD1V2_SEL;
    input (* integer supplySensitivity = "V_SUPPLY"; integer groundSensitivity = "GND"; *) UVLO_GD_OR_OVERRIDE_MPOS;
    logic UVLO_GD_OR_OVERRIDE_MPOS;
    input (* integer supplySensitivity = "V_SUPPLY"; integer groundSensitivity = "GND"; *) HIGH_POWER_MODE;
    logic HIGH_POWER_MODE;
    input (* integer supplySensitivity = "V_SUPPLY"; integer groundSensitivity = "GND"; *) SCAN_MODE_VSUPPLY;
    logic SCAN_MODE_VSUPPLY;
    input (* integer supplySensitivity = "V_SUPPLY"; integer groundSensitivity = "GND"; *) EN_SCAN_MODE_MPOS;
    logic EN_SCAN_MODE_MPOS;
    input (* integer supplySensitivity = "V_SUPPLY"; integer groundSensitivity = "GND"; *) FS_V_SUPPLY_TO_MOST_POS;
    logic FS_V_SUPPLY_TO_MOST_POS;
    input (* integer supplySensitivity = "V_SUPPLY"; integer groundSensitivity = "GND"; *) SREF_ADD_LDO1V2_LOAD_MPOS;
    logic SREF_ADD_LDO1V2_LOAD_MPOS;
    input (* integer supplySensitivity = "V_SUPPLY"; integer groundSensitivity = "GND"; *) SREF_EN_ISENSE_LDO1V2_MPOS;
    logic SREF_EN_ISENSE_LDO1V2_MPOS;
    input (* integer supplySensitivity = "V_SUPPLY"; integer groundSensitivity = "GND"; *) SREF_LDO_ISNS_DIS_MPOS;
    logic SREF_LDO_ISNS_DIS_MPOS;

    parameter integer DISABLED = 0;
    parameter integer REGULATION = 1;
    parameter integer REGULATION_2 = 2;
    parameter integer REGULATION_3 = 3;
    parameter integer REGULATION_4 = 4;
    parameter integer REGULATION_5 = 5;
    parameter integer DISABLED_2 = 6;
    parameter integer REGULATION_6 = 7;
    parameter integer REGULATION_7 = 8;
    parameter integer REGULATION_8 = 9;
    parameter integer REGULATION_9 = 10;
    parameter integer REGULATION_10 = 11;
    parameter integer REGULATION_11 = 12;
    parameter integer REGULATION_12 = 13;

    integer current_state;  // digital-domain FSM state

    analog begin

        @(initial_step) begin
            current_state = 0;
        end

        // ── Pin operating-range self-checks ──
        if ((V(VPWR) < 4.5) || (V(VPWR) > 5.5))
            $strobe("[%m] VPWR out of range: %g (expected [4.5, 5.5] voltage)", V(VPWR));
        if ((V(GND) < -0.1) || (V(GND) > 0.1))
            $strobe("[%m] GND out of range: %g (expected [-0.1, 0.1] voltage)", V(GND));
        if ((I(IBIAS_SNK_25nA_0) < 0) || (I(IBIAS_SNK_25nA_0) > 3e-08))
            $strobe("[%m] IBIAS_SNK_25nA_0 out of range: %g (expected [0, 3e-08] current)", I(IBIAS_SNK_25nA_0));
        if ((I(IBIAS_SNK_25nA_1) < 0) || (I(IBIAS_SNK_25nA_1) > 3e-08))
            $strobe("[%m] IBIAS_SNK_25nA_1 out of range: %g (expected [0, 3e-08] current)", I(IBIAS_SNK_25nA_1));
        if ((I(IBIAS_SNK_25nA_2) < 0) || (I(IBIAS_SNK_25nA_2) > 3e-08))
            $strobe("[%m] IBIAS_SNK_25nA_2 out of range: %g (expected [0, 3e-08] current)", I(IBIAS_SNK_25nA_2));
        if ((I(ICONST_75A) < 0) || (I(ICONST_75A) > 0.9))
            $strobe("[%m] ICONST_75A out of range: %g (expected [0, 0.9] current)", I(ICONST_75A));
        if ((V(AVSS) < -0.1) || (V(AVSS) > 0.1))
            $strobe("[%m] AVSS out of range: %g (expected [-0.1, 0.1] voltage)", V(AVSS));
        if ((V(PBKG) < -0.1) || (V(PBKG) > 0.1))
            $strobe("[%m] PBKG out of range: %g (expected [-0.1, 0.1] voltage)", V(PBKG));
        if ((V(FUN_DC) < 4.5) || (V(FUN_DC) > 5.5))
            $strobe("[%m] FUN_DC out of range: %g (expected [4.5, 5.5] voltage)", V(FUN_DC));
        if ((V(ISO) < 4.5) || (V(ISO) > 5.5))
            $strobe("[%m] ISO out of range: %g (expected [4.5, 5.5] voltage)", V(ISO));
        if ((V(MOST_POS) < 4.5) || (V(MOST_POS) > 5.5))
            $strobe("[%m] MOST_POS out of range: %g (expected [4.5, 5.5] voltage)", V(MOST_POS));
        if ((V(VDD_1V2) < 1.1) || (V(VDD_1V2) > 1.3))
            $strobe("[%m] VDD_1V2 out of range: %g (expected [1.1, 1.3] voltage)", V(VDD_1V2));
        if ((V(VDD_1V2_EXT) < 1.1) || (V(VDD_1V2_EXT) > 1.3))
            $strobe("[%m] VDD_1V2_EXT out of range: %g (expected [1.1, 1.3] voltage)", V(VDD_1V2_EXT));
        if ((V(V_SUPPLY) < 4.5) || (V(V_SUPPLY) > 5.5))
            $strobe("[%m] V_SUPPLY out of range: %g (expected [4.5, 5.5] voltage)", V(V_SUPPLY));

        // ── Digital-domain state-transition logic ──
        case (current_state)
            DISABLED: begin
                // condition: EN_LDO == 1
                if (EN_LDO)
                    current_state = REGULATION;
            end
            REGULATION: begin
                // condition: EN_LDO == 0
                // condition: HIGH_POWER_MODE == 1
                if (!EN_LDO && HIGH_POWER_MODE)
                    current_state = DISABLED_2;
                // condition: SREF_ADD_LDO1V2_LOAD_MPOS == 1
                // condition: VPWR_SEL == 0
                else if (SREF_ADD_LDO1V2_LOAD_MPOS && !VPWR_SEL)
                    current_state = REGULATION_11;
                // condition: EN_LDO == 0
                else if (!EN_LDO)
                    current_state = DISABLED;
                // condition: VPWR_SEL == 0
                else if (!VPWR_SEL)
                    current_state = REGULATION_2;
                // condition: HIGH_POWER_MODE == 1
                else if (HIGH_POWER_MODE)
                    current_state = REGULATION_5;
                // condition: SCAN_MODE_VSUPPLY == 1
                else if (SCAN_MODE_VSUPPLY)
                    current_state = REGULATION_6;
            end
            REGULATION_2: begin
                // condition: HIGH_POWER_MODE == 1
                // condition: VPWR_SEL == 1
                if (HIGH_POWER_MODE && VPWR_SEL)
                    current_state = REGULATION_5;
                // condition: VPWR_SEL == 1
                else if (VPWR_SEL)
                    current_state = REGULATION;
                // condition: HIGH_POWER_MODE == 1
                else if (HIGH_POWER_MODE)
                    current_state = REGULATION_3;
                // condition: SREF_ADD_LDO1V2_LOAD_MPOS == 1
                else if (SREF_ADD_LDO1V2_LOAD_MPOS)
                    current_state = REGULATION_11;
            end
            REGULATION_3: begin
                // condition: SREF_ADD_LDO1V2_LOAD_MPOS == 1
                if (SREF_ADD_LDO1V2_LOAD_MPOS)
                    current_state = REGULATION_4;
                // condition: VPWR_SEL == 1
                else if (VPWR_SEL)
                    current_state = REGULATION_5;
            end
            REGULATION_4: begin
                // condition: HIGH_POWER_MODE == 0
                // condition: SREF_ADD_LDO1V2_LOAD_MPOS == 0
                if (!HIGH_POWER_MODE && !SREF_ADD_LDO1V2_LOAD_MPOS)
                    current_state = REGULATION_2;
            end
            REGULATION_5: begin
                // condition: HIGH_POWER_MODE == 0
                if (!HIGH_POWER_MODE)
                    current_state = REGULATION;
            end
            DISABLED_2: begin
                // condition: EN_LDO == 1
                if (EN_LDO)
                    current_state = REGULATION_5;
            end
            REGULATION_6: begin
                // condition: EN_SCAN_MODE_MPOS == 1
                // condition: SCAN_MODE_VSUPPLY == 0
                if (EN_SCAN_MODE_MPOS && !SCAN_MODE_VSUPPLY)
                    current_state = REGULATION_7;
            end
            REGULATION_7: begin
                // condition: SCAN_MODE_VSUPPLY == 1
                if (SCAN_MODE_VSUPPLY)
                    current_state = REGULATION_8;
            end
            REGULATION_8: begin
                // condition: SREF_ADD_LDO1V2_LOAD_MPOS == 1
                if (SREF_ADD_LDO1V2_LOAD_MPOS)
                    current_state = REGULATION_9;
            end
            REGULATION_9: begin
                // condition: EN_SCAN_MODE_MPOS == 0
                // condition: SCAN_MODE_VSUPPLY == 0
                if (!EN_SCAN_MODE_MPOS && !SCAN_MODE_VSUPPLY)
                    current_state = REGULATION_10;
            end
            REGULATION_10: begin
                // condition: SREF_ADD_LDO1V2_LOAD_MPOS == 0
                if (!SREF_ADD_LDO1V2_LOAD_MPOS)
                    current_state = REGULATION;
            end
            REGULATION_11: begin
                // condition: EN_SCAN_MODE_MPOS == 1
                // condition: SCAN_MODE_VSUPPLY == 1
                if (EN_SCAN_MODE_MPOS && SCAN_MODE_VSUPPLY)
                    current_state = REGULATION_12;
            end
            REGULATION_12: begin
                // condition: EN_SCAN_MODE_MPOS == 0
                // condition: SCAN_MODE_VSUPPLY == 0
                // condition: SREF_ADD_LDO1V2_LOAD_MPOS == 0
                if (!EN_SCAN_MODE_MPOS && !SCAN_MODE_VSUPPLY && !SREF_ADD_LDO1V2_LOAD_MPOS)
                    current_state = REGULATION_2;
            end
        endcase

        // ── Fitted per-state output equations (Phase 2 modeling) ──
        case (current_state)
            DISABLED: begin
                I(FUN_DC, GND) <+ -2.98644e-06*V(VPWR) + 0.000405515*V(VREF) + -2.98644e-06*V(FUN_DC) + -2.98643e-06*V(V_SUPPLY) + -2.98644e-06*V(MOST_POS) + 8.84817e-05*V(EN_LDO) + 0.000291774*meta_corner + -9.59685e-07*meta_temp + -7.1287e-05*meta_vsup_max + 3.09871e-07*V(VPWR)*V(VPWR) + -7.6307e-06*V(VPWR)*V(VREF) + 3.09871e-07*V(VPWR)*V(FUN_DC) + 3.09871e-07*V(VPWR)*V(V_SUPPLY) + 3.09871e-07*V(VPWR)*V(MOST_POS) + 9.3376e-06*V(VPWR)*V(EN_LDO) + 4.98732e-08*V(VPWR)*meta_corner + 3.4025e-09*V(VPWR)*meta_temp + -3.42272e-07*V(VPWR)*meta_vsup_max + -0.00060609*V(VREF)*V(VREF) + -7.6307e-06*V(VREF)*V(FUN_DC) + -7.6307e-06*V(VREF)*V(V_SUPPLY) + -7.6307e-06*V(VREF)*V(MOST_POS) + 6.19372e-05*V(VREF)*V(EN_LDO) + -5.07308e-05*V(VREF)*meta_corner + -2.69664e-07*V(VREF)*meta_temp + -7.6307e-06*V(VREF)*meta_vsup_max + 3.09871e-07*V(FUN_DC)*V(FUN_DC) + 3.09871e-07*V(FUN_DC)*V(V_SUPPLY) + 3.09871e-07*V(FUN_DC)*V(MOST_POS) + 9.3376e-06*V(FUN_DC)*V(EN_LDO) + 4.98732e-08*V(FUN_DC)*meta_corner + 3.40247e-09*V(FUN_DC)*meta_temp + -3.42272e-07*V(FUN_DC)*meta_vsup_max + 3.09871e-07*V(V_SUPPLY)*V(V_SUPPLY) + 3.09871e-07*V(V_SUPPLY)*V(MOST_POS) + 9.3376e-06*V(V_SUPPLY)*V(EN_LDO) + 4.98732e-08*V(V_SUPPLY)*meta_corner + 3.40268e-09*V(V_SUPPLY)*meta_temp + -3.42272e-07*V(V_SUPPLY)*meta_vsup_max + 3.09871e-07*V(MOST_POS)*V(MOST_POS) + 9.3376e-06*V(MOST_POS)*V(EN_LDO) + 4.98732e-08*V(MOST_POS)*meta_corner + 3.4025e-09*V(MOST_POS)*meta_temp + -3.42272e-07*V(MOST_POS)*meta_vsup_max + -0.000219783*V(EN_LDO)*V(EN_LDO) + -7.54803e-05*V(EN_LDO)*meta_corner + 1.71264e-07*V(EN_LDO)*meta_temp + 9.3376e-06*V(EN_LDO)*meta_vsup_max + 0.000808405*meta_corner*meta_corner + 2.05965e-07*meta_corner*meta_temp + -1.24372e-05*meta_corner*meta_vsup_max + -2.02075e-10*meta_temp*meta_temp + 1.9695e-07*meta_temp*meta_vsup_max + 6.55605e-06*meta_vsup_max*meta_vsup_max + 0.000501304*idt(V(VPWR)) + -0.155217*idt(V(VREF)) + 0.000501304*idt(V(FUN_DC)) + 0.000501304*idt(V(V_SUPPLY)) + 0.000501304*idt(V(MOST_POS)) + 0.0226327*idt(V(EN_LDO)) + 0.000186364;  // FUN_DC_I
                I(MOST_POS, GND) <+ -1.42903e-05*V(VPWR) + 0.00813066*V(VREF) + -1.42903e-05*V(FUN_DC) + -1.42902e-05*V(V_SUPPLY) + -1.42902e-05*V(MOST_POS) + 0.00107019*V(EN_LDO) + -0.00164217*meta_corner + -8.88683e-06*meta_temp + -0.00259642*meta_vsup_max + -4.6385e-06*V(VPWR)*V(VPWR) + -0.000243495*V(VPWR)*V(VREF) + -4.6385e-06*V(VPWR)*V(FUN_DC) + -4.6385e-06*V(VPWR)*V(V_SUPPLY) + -4.6385e-06*V(VPWR)*V(MOST_POS) + 6.60195e-05*V(VPWR)*V(EN_LDO) + -2.01971e-06*V(VPWR)*meta_corner + 8.36181e-09*V(VPWR)*meta_temp + 1.45937e-05*V(VPWR)*meta_vsup_max + -0.0120235*V(VREF)*V(VREF) + -0.000243495*V(VREF)*V(FUN_DC) + -0.000243495*V(VREF)*V(V_SUPPLY) + -0.000243495*V(VREF)*V(MOST_POS) + 0.000749133*V(VREF)*V(EN_LDO) + -0.00411696*V(VREF)*meta_corner + 3.85685e-06*V(VREF)*meta_temp + -0.000243495*V(VREF)*meta_vsup_max + -4.6385e-06*V(FUN_DC)*V(FUN_DC) + -4.6385e-06*V(FUN_DC)*V(V_SUPPLY) + -4.6385e-06*V(FUN_DC)*V(MOST_POS) + 6.60195e-05*V(FUN_DC)*V(EN_LDO) + -2.01971e-06*V(FUN_DC)*meta_corner + 8.36109e-09*V(FUN_DC)*meta_temp + 1.45937e-05*V(FUN_DC)*meta_vsup_max + -4.6385e-06*V(V_SUPPLY)*V(V_SUPPLY) + -4.6385e-06*V(V_SUPPLY)*V(MOST_POS) + 6.60195e-05*V(V_SUPPLY)*V(EN_LDO) + -2.01971e-06*V(V_SUPPLY)*meta_corner + 8.36658e-09*V(V_SUPPLY)*meta_temp + 1.45937e-05*V(V_SUPPLY)*meta_vsup_max + -4.6385e-06*V(MOST_POS)*V(MOST_POS) + 6.60195e-05*V(MOST_POS)*V(EN_LDO) + -2.01971e-06*V(MOST_POS)*meta_corner + 8.36195e-09*V(MOST_POS)*meta_temp + 1.45937e-05*V(MOST_POS)*meta_vsup_max + -0.000361922*V(EN_LDO)*V(EN_LDO) + 0.00190933*V(EN_LDO)*meta_corner + -3.40878e-06*V(EN_LDO)*meta_temp + 6.60195e-05*V(EN_LDO)*meta_vsup_max + -0.00739336*meta_corner*meta_corner + 6.76166e-07*meta_corner*meta_temp + -9.57781e-05*meta_corner*meta_vsup_max + 4.74111e-09*meta_temp*meta_temp + 1.73354e-06*meta_temp*meta_vsup_max + 0.000248761*meta_vsup_max*meta_vsup_max + -1.01076e-09*ddt(V(VPWR)) + 2.19759e-09*ddt(V(VREF)) + -4.46291e-10*ddt(V(FUN_DC)) + 7.19126e-10*ddt(V(V_SUPPLY)) + 7.34011e-10*ddt(V(MOST_POS)) + 0.0157948*idt(V(VPWR)) + -3.95244*idt(V(VREF)) + 0.0157948*idt(V(FUN_DC)) + 0.0157948*idt(V(V_SUPPLY)) + 0.0157948*idt(V(MOST_POS)) + 0.582393*idt(V(EN_LDO)) + 0.0067251;  // MOST_POS_I
                V(VDD_1V2) <+ -0.00762605*V(VPWR) + 0.863533*V(VREF) + -0.00762605*V(FUN_DC) + -0.00762605*V(V_SUPPLY) + -0.00762605*V(MOST_POS) + 0.0745056*V(EN_LDO) + 1.03453*meta_corner + -0.000662117*meta_temp + 0.0437489*meta_vsup_max + 0.00133515*V(VPWR)*V(VPWR) + -0.0138105*V(VPWR)*V(VREF) + 0.00133515*V(VPWR)*V(FUN_DC) + 0.00133515*V(VPWR)*V(V_SUPPLY) + 0.00133515*V(VPWR)*V(MOST_POS) + 0.0058676*V(VPWR)*V(EN_LDO) + 8.54751e-05*V(VPWR)*meta_corner + 4.63407e-06*V(VPWR)*meta_temp + -0.00248257*V(VPWR)*meta_vsup_max + -0.897332*V(VREF)*V(VREF) + -0.0138105*V(VREF)*V(FUN_DC) + -0.0138105*V(VREF)*V(V_SUPPLY) + -0.0138105*V(VREF)*V(MOST_POS) + 0.0521539*V(VREF)*V(EN_LDO) + 1.53479*V(VREF)*meta_corner + 0.00121273*V(VREF)*meta_temp + -0.0138105*V(VREF)*meta_vsup_max + 0.00133515*V(FUN_DC)*V(FUN_DC) + 0.00133515*V(FUN_DC)*V(V_SUPPLY) + 0.00133515*V(FUN_DC)*V(MOST_POS) + 0.0058676*V(FUN_DC)*V(EN_LDO) + 8.54751e-05*V(FUN_DC)*meta_corner + 4.63402e-06*V(FUN_DC)*meta_temp + -0.00248257*V(FUN_DC)*meta_vsup_max + 0.00133515*V(V_SUPPLY)*V(V_SUPPLY) + 0.00133515*V(V_SUPPLY)*V(MOST_POS) + 0.0058676*V(V_SUPPLY)*V(EN_LDO) + 8.54751e-05*V(V_SUPPLY)*meta_corner + 4.63437e-06*V(V_SUPPLY)*meta_temp + -0.00248257*V(V_SUPPLY)*meta_vsup_max + 0.00133515*V(MOST_POS)*V(MOST_POS) + 0.0058676*V(MOST_POS)*V(EN_LDO) + 8.54751e-05*V(MOST_POS)*meta_corner + 4.63408e-06*V(MOST_POS)*meta_temp + -0.00248257*V(MOST_POS)*meta_vsup_max + -0.0766767*V(EN_LDO)*V(EN_LDO) + -0.0140028*V(EN_LDO)*meta_corner + -9.5487e-05*V(EN_LDO)*meta_temp + 0.0058676*V(EN_LDO)*meta_vsup_max + 3.64215*meta_corner*meta_corner + -0.00030536*meta_corner*meta_temp + 0.00456192*meta_corner*meta_vsup_max + -1.48499e-06*meta_temp*meta_temp + -9.23923e-05*meta_temp*meta_vsup_max + -0.00322914*meta_vsup_max*meta_vsup_max + -6.11228e-08*ddt(V(VPWR)) + 4.59039e-08*ddt(V(VREF)) + -2.56364e-08*ddt(V(FUN_DC)) + 4.78879e-08*ddt(V(V_SUPPLY)) + 4.88237e-08*ddt(V(MOST_POS)) + -1.3789e-09*ddt(V(EN_LDO)) + 0.400426*idt(V(VPWR)) + -249.668*idt(V(VREF)) + 0.400426*idt(V(FUN_DC)) + 0.400426*idt(V(V_SUPPLY)) + 0.400426*idt(V(MOST_POS)) + 25.2578*idt(V(EN_LDO)) + -0.00750347;
                I(VPWR, GND) <+ 0.0002177*V(VPWR) + -0.0585191*V(VREF) + 0.000217701*V(FUN_DC) + 0.0002177*V(V_SUPPLY) + 0.0002177*V(MOST_POS) + -0.00382972*V(EN_LDO) + -0.00993043*meta_corner + 6.83376e-05*meta_temp + -0.00245572*meta_vsup_max + -1.55039e-05*V(VPWR)*V(VPWR) + 0.00148442*V(VPWR)*V(VREF) + -1.55039e-05*V(VPWR)*V(FUN_DC) + -1.55039e-05*V(VPWR)*V(V_SUPPLY) + -1.55039e-05*V(VPWR)*V(MOST_POS) + -0.00170453*V(VPWR)*V(EN_LDO) + -4.06095e-05*V(VPWR)*meta_corner + -3.90523e-07*V(VPWR)*meta_temp + 7.48433e-06*V(VPWR)*meta_vsup_max + 0.069709*V(VREF)*V(VREF) + 0.00148442*V(VREF)*V(FUN_DC) + 0.00148442*V(VREF)*V(V_SUPPLY) + 0.00148442*V(VREF)*V(MOST_POS) + -0.0026808*V(VREF)*V(EN_LDO) + 0.0173708*V(VREF)*meta_corner + 5.65069e-05*V(VREF)*meta_temp + 0.00148442*V(VREF)*meta_vsup_max + -1.55039e-05*V(FUN_DC)*V(FUN_DC) + -1.55039e-05*V(FUN_DC)*V(V_SUPPLY) + -1.55039e-05*V(FUN_DC)*V(MOST_POS) + -0.00170453*V(FUN_DC)*V(EN_LDO) + -4.06095e-05*V(FUN_DC)*meta_corner + -3.9052e-07*V(FUN_DC)*meta_temp + 7.48433e-06*V(FUN_DC)*meta_vsup_max + -1.55039e-05*V(V_SUPPLY)*V(V_SUPPLY) + -1.55039e-05*V(V_SUPPLY)*V(MOST_POS) + -0.00170453*V(V_SUPPLY)*V(EN_LDO) + -4.06095e-05*V(V_SUPPLY)*meta_corner + -3.90543e-07*V(V_SUPPLY)*meta_temp + 7.48433e-06*V(V_SUPPLY)*meta_vsup_max + -1.55039e-05*V(MOST_POS)*V(MOST_POS) + -0.00170453*V(MOST_POS)*V(EN_LDO) + -4.06095e-05*V(MOST_POS)*meta_corner + -3.90523e-07*V(MOST_POS)*meta_temp + 7.48433e-06*V(MOST_POS)*meta_vsup_max + 0.0292422*V(EN_LDO)*V(EN_LDO) + -0.00205219*V(EN_LDO)*meta_corner + -4.42355e-05*V(EN_LDO)*meta_temp + -0.00170453*V(EN_LDO)*meta_vsup_max + -0.04008*meta_corner*meta_corner + -2.09473e-05*meta_corner*meta_temp + -0.000174361*meta_corner*meta_vsup_max + 1.87688e-08*meta_temp*meta_temp + -1.40133e-05*meta_temp*meta_vsup_max + 0.000274805*meta_vsup_max*meta_vsup_max + 4.13948e-09*ddt(V(VPWR)) + -8.31702e-09*ddt(V(VREF)) + 1.80743e-09*ddt(V(FUN_DC)) + -3.05654e-09*ddt(V(V_SUPPLY)) + -3.1182e-09*ddt(V(MOST_POS)) + 3.72018e-10*ddt(V(EN_LDO)) + -0.0860528*idt(V(VPWR)) + 16.4588*idt(V(VREF)) + -0.0860528*idt(V(FUN_DC)) + -0.0860528*idt(V(V_SUPPLY)) + -0.0860528*idt(V(MOST_POS)) + -2.31519*idt(V(EN_LDO)) + 0.00558022;  // VPWR_I
                I(V_SUPPLY, GND) <+ 1.91918e-06*V(VPWR) + -2.35208e-05*V(VREF) + 1.91918e-06*V(FUN_DC) + 1.91918e-06*V(V_SUPPLY) + 1.91918e-06*V(MOST_POS) + 1.28259e-05*V(EN_LDO) + -0.000266553*meta_corner + 2.19256e-07*meta_temp + 3.43954e-05*meta_vsup_max + -3.55455e-07*V(VPWR)*V(VPWR) + -5.17063e-07*V(VPWR)*V(VREF) + -3.55455e-07*V(VPWR)*V(FUN_DC) + -3.55455e-07*V(VPWR)*V(V_SUPPLY) + -3.55455e-07*V(VPWR)*V(MOST_POS) + 6.68546e-06*V(VPWR)*V(EN_LDO) + -2.39188e-07*V(VPWR)*meta_corner + -2.4763e-09*V(VPWR)*meta_temp + 6.26463e-07*V(VPWR)*meta_vsup_max + -2.91883e-05*V(VREF)*V(VREF) + -5.17063e-07*V(VREF)*V(FUN_DC) + -5.17063e-07*V(VREF)*V(V_SUPPLY) + -5.17063e-07*V(VREF)*V(MOST_POS) + 8.9781e-06*V(VREF)*V(EN_LDO) + 5.65498e-05*V(VREF)*meta_corner + 1.75301e-07*V(VREF)*meta_temp + -5.17063e-07*V(VREF)*meta_vsup_max + -3.55455e-07*V(FUN_DC)*V(FUN_DC) + -3.55455e-07*V(FUN_DC)*V(V_SUPPLY) + -3.55455e-07*V(FUN_DC)*V(MOST_POS) + 6.68546e-06*V(FUN_DC)*V(EN_LDO) + -2.39188e-07*V(FUN_DC)*meta_corner + -2.4763e-09*V(FUN_DC)*meta_temp + 6.26463e-07*V(FUN_DC)*meta_vsup_max + -3.55455e-07*V(V_SUPPLY)*V(V_SUPPLY) + -3.55455e-07*V(V_SUPPLY)*V(MOST_POS) + 6.68546e-06*V(V_SUPPLY)*V(EN_LDO) + -2.39188e-07*V(V_SUPPLY)*meta_corner + -2.47629e-09*V(V_SUPPLY)*meta_temp + 6.26463e-07*V(V_SUPPLY)*meta_vsup_max + -3.55455e-07*V(MOST_POS)*V(MOST_POS) + 6.68546e-06*V(MOST_POS)*V(EN_LDO) + -2.39188e-07*V(MOST_POS)*meta_corner + -2.4763e-09*V(MOST_POS)*meta_temp + 6.26463e-07*V(MOST_POS)*meta_vsup_max + -2.98537e-05*V(EN_LDO)*V(EN_LDO) + 4.60383e-05*V(EN_LDO)*meta_corner + -2.53209e-07*V(EN_LDO)*meta_temp + 6.68546e-06*V(EN_LDO)*meta_vsup_max + -0.000736261*meta_corner*meta_corner + -1.31443e-07*meta_corner*meta_temp + 1.18862e-05*meta_corner*meta_vsup_max + 3.71229e-10*meta_temp*meta_temp + -4.80465e-08*meta_temp*meta_vsup_max + -3.34617e-06*meta_vsup_max*meta_vsup_max + -4.09731e-06*idt(V(VPWR)) + -0.00280238*idt(V(VREF)) + -4.09731e-06*idt(V(FUN_DC)) + -4.09731e-06*idt(V(V_SUPPLY)) + -4.09731e-06*idt(V(MOST_POS)) + 0.000476878*idt(V(EN_LDO)) + -8.61229e-05;  // V_SUPPLY_I
            end
            REGULATION: begin
                I(FUN_DC, GND) <+ 2.43985e-05*V(VPWR) + -0.000194121*V(VREF) + 2.59302e-05*V(FUN_DC) + 2.59302e-05*V(V_SUPPLY) + 2.59302e-05*V(MOST_POS) + 4.12175e-07*V(EN_LDO) + -6.4848e-07*meta_corner + -6.64659e-09*meta_temp + 2.59302e-05*meta_vsup_max + -2.14669e-07*V(VPWR)*V(VPWR) + 1.70789e-05*V(VPWR)*V(VREF) + -2.28269e-07*V(VPWR)*V(FUN_DC) + -2.28269e-07*V(VPWR)*V(V_SUPPLY) + -2.28269e-07*V(VPWR)*V(MOST_POS) + -6.13592e-06*V(VPWR)*V(EN_LDO) + -1.75544e-06*V(VPWR)*meta_corner + 1.78671e-08*V(VPWR)*meta_temp + -2.28269e-07*V(VPWR)*meta_vsup_max + -0.000135885*V(VREF)*V(VREF) + 1.81511e-05*V(VREF)*V(FUN_DC) + 1.81511e-05*V(VREF)*V(V_SUPPLY) + 1.81511e-05*V(VREF)*V(MOST_POS) + 2.88523e-07*V(VREF)*V(EN_LDO) + -4.53936e-07*V(VREF)*meta_corner + -4.65263e-09*V(VREF)*meta_temp + 1.81511e-05*V(VREF)*meta_vsup_max + -1.78397e-06*V(FUN_DC)*V(FUN_DC) + -1.78397e-06*V(FUN_DC)*V(V_SUPPLY) + -1.78397e-06*V(FUN_DC)*V(MOST_POS) + 1.52276e-06*V(FUN_DC)*V(EN_LDO) + 6.29551e-08*V(FUN_DC)*meta_corner + -5.61817e-09*V(FUN_DC)*meta_temp + -1.78397e-06*V(FUN_DC)*meta_vsup_max + -1.78397e-06*V(V_SUPPLY)*V(V_SUPPLY) + -1.78397e-06*V(V_SUPPLY)*V(MOST_POS) + 1.52276e-06*V(V_SUPPLY)*V(EN_LDO) + 6.29551e-08*V(V_SUPPLY)*meta_corner + -5.61817e-09*V(V_SUPPLY)*meta_temp + -1.78397e-06*V(V_SUPPLY)*meta_vsup_max + -1.78397e-06*V(MOST_POS)*V(MOST_POS) + 1.52276e-06*V(MOST_POS)*V(EN_LDO) + 6.29551e-08*V(MOST_POS)*meta_corner + -5.61811e-09*V(MOST_POS)*meta_temp + -1.78397e-06*V(MOST_POS)*meta_vsup_max + -1.85631e-09*V(EN_LDO)*V(EN_LDO) + 1.39755e-06*V(EN_LDO)*meta_corner + 6.95842e-10*V(EN_LDO)*meta_temp + 1.52276e-06*V(EN_LDO)*meta_vsup_max + -3.56403e-06*meta_corner*meta_corner + -3.90119e-09*meta_corner*meta_temp + 6.29551e-08*meta_corner*meta_vsup_max + 3.49541e-10*meta_temp*meta_temp + -5.61817e-09*meta_temp*meta_vsup_max + -1.78397e-06*meta_vsup_max*meta_vsup_max + -3.29981e-05*ddt(V(VREF)) + -0.000531682*ddt(V(FUN_DC)) + -0.000531682*ddt(V(V_SUPPLY)) + -0.000531682*ddt(V(MOST_POS)) + 4.06953e-05*idt(V(VPWR)) + 0.000237205*idt(V(VREF)) + -2.44263e-05*idt(V(FUN_DC)) + -2.44263e-05*idt(V(V_SUPPLY)) + -2.44263e-05*idt(V(MOST_POS)) + 8.54092e-06*idt(V(EN_LDO)) + -0.000277316;  // FUN_DC_I
                I(MOST_POS, GND) <+ -1.91338e-05*V(VPWR) + 0.000818963*V(VREF) + -1.81733e-05*V(FUN_DC) + -1.81733e-05*V(V_SUPPLY) + -1.81733e-05*V(MOST_POS) + -0.000552466*V(EN_LDO) + -0.000178283*meta_corner + 9.29134e-09*meta_temp + -1.81733e-05*meta_vsup_max + 8.86915e-06*V(VPWR)*V(VPWR) + -1.33937e-05*V(VPWR)*V(VREF) + -1.13015e-06*V(VPWR)*V(FUN_DC) + -1.13015e-06*V(VPWR)*V(V_SUPPLY) + -1.13015e-06*V(VPWR)*V(MOST_POS) + 5.34249e-06*V(VPWR)*V(EN_LDO) + 0.000131897*V(VPWR)*meta_corner + 7.00843e-08*V(VPWR)*meta_temp + -1.13015e-06*V(VPWR)*meta_vsup_max + 0.000573273*V(VREF)*V(VREF) + -1.27213e-05*V(VREF)*V(FUN_DC) + -1.27213e-05*V(VREF)*V(V_SUPPLY) + -1.27213e-05*V(VREF)*V(MOST_POS) + -0.000386726*V(VREF)*V(EN_LDO) + -0.000124798*V(VREF)*meta_corner + 6.50083e-09*V(VREF)*meta_temp + -1.27213e-05*V(VREF)*meta_vsup_max + -4.71114e-07*V(FUN_DC)*V(FUN_DC) + -4.71114e-07*V(FUN_DC)*V(V_SUPPLY) + -4.71114e-07*V(FUN_DC)*V(MOST_POS) + 1.01452e-05*V(FUN_DC)*V(EN_LDO) + -3.82721e-05*V(FUN_DC)*meta_corner + -1.17871e-08*V(FUN_DC)*meta_temp + -4.71114e-07*V(FUN_DC)*meta_vsup_max + -4.71114e-07*V(V_SUPPLY)*V(V_SUPPLY) + -4.71114e-07*V(V_SUPPLY)*V(MOST_POS) + 1.01452e-05*V(V_SUPPLY)*V(EN_LDO) + -3.82721e-05*V(V_SUPPLY)*meta_corner + -1.17877e-08*V(V_SUPPLY)*meta_temp + -4.71114e-07*V(V_SUPPLY)*meta_vsup_max + -4.71114e-07*V(MOST_POS)*V(MOST_POS) + 1.01452e-05*V(MOST_POS)*V(EN_LDO) + -3.82721e-05*V(MOST_POS)*meta_corner + -1.17764e-08*V(MOST_POS)*meta_temp + -4.71114e-07*V(MOST_POS)*meta_vsup_max + 7.77584e-05*V(EN_LDO)*V(EN_LDO) + -1.60175e-05*V(EN_LDO)*meta_corner + 2.56441e-08*V(EN_LDO)*meta_temp + 1.01452e-05*V(EN_LDO)*meta_vsup_max + -0.00185125*meta_corner*meta_corner + 8.71639e-07*meta_corner*meta_temp + -3.82721e-05*meta_corner*meta_vsup_max + -4.18459e-09*meta_temp*meta_temp + -1.1788e-08*meta_temp*meta_vsup_max + -4.71114e-07*meta_vsup_max*meta_vsup_max + -0.00632612*ddt(V(VREF)) + -0.101929*ddt(V(FUN_DC)) + -0.101929*ddt(V(V_SUPPLY)) + -0.101929*ddt(V(MOST_POS)) + 0.0103174*idt(V(VPWR)) + 0.0187593*idt(V(VREF)) + -0.00366341*idt(V(FUN_DC)) + -0.00366341*idt(V(V_SUPPLY)) + -0.00366341*idt(V(MOST_POS)) + -0.00264989*idt(V(EN_LDO)) + 0.00116995;  // MOST_POS_I
                V(VDD_1V2) <+ -0.0286803*V(VPWR) + 2.53447*V(VREF) + -0.0397524*V(FUN_DC) + -0.0397524*V(V_SUPPLY) + -0.0397524*V(MOST_POS) + -2.29022*V(EN_LDO) + 3.60818*meta_corner + 0.001576*meta_temp + -0.0397524*meta_vsup_max + 0.000599426*V(VPWR)*V(VPWR) + -0.0200762*V(VPWR)*V(VREF) + -0.0140013*V(VPWR)*V(FUN_DC) + -0.0140013*V(VPWR)*V(V_SUPPLY) + -0.0140013*V(VPWR)*V(MOST_POS) + 0.0558924*V(VPWR)*V(EN_LDO) + -0.656717*V(VPWR)*meta_corner + -0.00024079*V(VPWR)*meta_temp + -0.0140013*V(VPWR)*meta_vsup_max + 1.77413*V(VREF)*V(VREF) + -0.0278267*V(VREF)*V(FUN_DC) + -0.0278267*V(VREF)*V(V_SUPPLY) + -0.0278267*V(VREF)*V(MOST_POS) + -1.60315*V(VREF)*V(EN_LDO) + 2.52572*V(VREF)*meta_corner + 0.0011032*V(VREF)*meta_temp + -0.0278267*V(VREF)*meta_vsup_max + 0.00606569*V(FUN_DC)*V(FUN_DC) + 0.00606569*V(FUN_DC)*V(V_SUPPLY) + 0.00606569*V(FUN_DC)*V(MOST_POS) + 0.00053179*V(FUN_DC)*V(EN_LDO) + 0.195377*V(FUN_DC)*meta_corner + -0.000138203*V(FUN_DC)*meta_temp + 0.00606569*V(FUN_DC)*meta_vsup_max + 0.00606569*V(V_SUPPLY)*V(V_SUPPLY) + 0.00606569*V(V_SUPPLY)*V(MOST_POS) + 0.00053179*V(V_SUPPLY)*V(EN_LDO) + 0.195377*V(V_SUPPLY)*meta_corner + -0.000138203*V(V_SUPPLY)*meta_temp + 0.00606569*V(V_SUPPLY)*meta_vsup_max + 0.00606569*V(MOST_POS)*V(MOST_POS) + 0.00053179*V(MOST_POS)*V(EN_LDO) + 0.195377*V(MOST_POS)*meta_corner + -0.000138213*V(MOST_POS)*meta_temp + 0.00606569*V(MOST_POS)*meta_vsup_max + 0.435159*V(EN_LDO)*V(EN_LDO) + -0.407211*V(EN_LDO)*meta_corner + -0.000454849*V(EN_LDO)*meta_temp + 0.00053179*V(EN_LDO)*meta_vsup_max + 6.19264*meta_corner*meta_corner + -0.0100502*meta_corner*meta_temp + 0.195377*meta_corner*meta_vsup_max + 3.39536e-05*meta_temp*meta_temp + -0.000138202*meta_temp*meta_vsup_max + 0.00606569*meta_vsup_max*meta_vsup_max + 7.00038e-08*ddt(V(VPWR)) + 5.61765*ddt(V(VREF)) + 90.5158*ddt(V(FUN_DC)) + 90.5158*ddt(V(V_SUPPLY)) + 90.5158*ddt(V(MOST_POS)) + 1.61912e-07*ddt(V(EN_LDO)) + 38.7243*idt(V(VPWR)) + -28.505*idt(V(VREF)) + -11.6268*idt(V(FUN_DC)) + -11.6268*idt(V(V_SUPPLY)) + -11.6268*idt(V(MOST_POS)) + -0.661165*idt(V(EN_LDO)) + 3.62067;
                I(VPWR, GND) <+ -0.00904696*V(VPWR) + 0.224573*V(VREF) + -0.0116061*V(FUN_DC) + -0.0116061*V(V_SUPPLY) + -0.0116061*V(MOST_POS) + -0.110253*V(EN_LDO) + -0.00866051*meta_corner + -0.000130619*meta_temp + -0.0116061*meta_vsup_max + -0.00695357*V(VPWR)*V(VPWR) + -0.00633287*V(VPWR)*V(VREF) + 0.00063385*V(VPWR)*V(FUN_DC) + 0.00063385*V(VPWR)*V(V_SUPPLY) + 0.00063385*V(VPWR)*V(MOST_POS) + 0.0115591*V(VPWR)*V(EN_LDO) + 0.00638945*V(VPWR)*meta_corner + 3.37675e-06*V(VPWR)*meta_temp + 0.00063385*V(VPWR)*meta_vsup_max + 0.157201*V(VREF)*V(VREF) + -0.00812425*V(VREF)*V(FUN_DC) + -0.00812425*V(VREF)*V(V_SUPPLY) + -0.00812425*V(VREF)*V(MOST_POS) + -0.0771772*V(VREF)*V(EN_LDO) + -0.00606236*V(VREF)*meta_corner + -9.14328e-05*V(VREF)*meta_temp + -0.00812425*V(VREF)*meta_vsup_max + 0.000925198*V(FUN_DC)*V(FUN_DC) + 0.000925198*V(FUN_DC)*V(V_SUPPLY) + 0.000925198*V(FUN_DC)*V(MOST_POS) + -0.0012364*V(FUN_DC)*V(EN_LDO) + -0.00232777*V(FUN_DC)*meta_corner + 1.55031e-06*V(FUN_DC)*meta_temp + 0.000925198*V(FUN_DC)*meta_vsup_max + 0.000925198*V(V_SUPPLY)*V(V_SUPPLY) + 0.000925198*V(V_SUPPLY)*V(MOST_POS) + -0.0012364*V(V_SUPPLY)*V(EN_LDO) + -0.00232777*V(V_SUPPLY)*meta_corner + 1.55035e-06*V(V_SUPPLY)*meta_temp + 0.000925198*V(V_SUPPLY)*meta_vsup_max + 0.000925198*V(MOST_POS)*V(MOST_POS) + -0.0012364*V(MOST_POS)*V(EN_LDO) + -0.00232777*V(MOST_POS)*meta_corner + 1.54961e-06*V(MOST_POS)*meta_temp + 0.000925198*V(MOST_POS)*meta_vsup_max + 0.0163914*V(EN_LDO)*V(EN_LDO) + -0.0139952*V(EN_LDO)*meta_corner + 3.87198e-05*V(EN_LDO)*meta_temp + -0.0012364*V(EN_LDO)*meta_vsup_max + -0.196979*meta_corner*meta_corner + -0.000130851*meta_corner*meta_temp + -0.00232777*meta_corner*meta_vsup_max + -1.61046e-07*meta_temp*meta_temp + 1.55037e-06*meta_temp*meta_vsup_max + 0.000925198*meta_vsup_max*meta_vsup_max + 9.46984e-09*ddt(V(VPWR)) + 0.415579*ddt(V(VREF)) + 6.69603*ddt(V(FUN_DC)) + 6.69603*ddt(V(V_SUPPLY)) + 6.69603*ddt(V(MOST_POS)) + -1.15496e-08*ddt(V(EN_LDO)) + 0.51492*idt(V(VPWR)) + -2.203*idt(V(VREF)) + -0.215686*idt(V(FUN_DC)) + -0.215686*idt(V(V_SUPPLY)) + -0.215686*idt(V(MOST_POS)) + 0.631081*idt(V(EN_LDO)) + 0.320818;  // VPWR_I
                I(V_SUPPLY, GND) <+ 2.50743e-05*V(VPWR) + 5.99069e-05*V(VREF) + 2.42293e-05*V(FUN_DC) + 2.42293e-05*V(V_SUPPLY) + 2.42293e-05*V(MOST_POS) + -0.000169216*V(EN_LDO) + 0.000224952*meta_corner + -6.80146e-07*meta_temp + 2.42293e-05*meta_vsup_max + 3.82751e-06*V(VPWR)*V(VPWR) + 1.7552e-05*V(VPWR)*V(VREF) + -1.49995e-06*V(VPWR)*V(FUN_DC) + -1.49995e-06*V(VPWR)*V(V_SUPPLY) + -1.49995e-06*V(VPWR)*V(MOST_POS) + -6.08453e-06*V(VPWR)*V(EN_LDO) + -3.77509e-06*V(VPWR)*meta_corner + 1.59532e-08*V(VPWR)*meta_temp + -1.49995e-06*V(VPWR)*meta_vsup_max + 4.19348e-05*V(VREF)*V(VREF) + 1.69605e-05*V(VREF)*V(FUN_DC) + 1.69605e-05*V(VREF)*V(V_SUPPLY) + 1.69605e-05*V(VREF)*V(MOST_POS) + -0.000118451*V(VREF)*V(EN_LDO) + 0.000157466*V(VREF)*meta_corner + -4.76102e-07*V(VREF)*meta_temp + 1.69605e-05*V(VREF)*meta_vsup_max + 7.9095e-07*V(FUN_DC)*V(FUN_DC) + 7.9095e-07*V(FUN_DC)*V(V_SUPPLY) + 7.9095e-07*V(FUN_DC)*V(MOST_POS) + -1.03095e-05*V(FUN_DC)*V(EN_LDO) + -2.44035e-06*V(FUN_DC)*meta_corner + 7.87704e-10*V(FUN_DC)*meta_temp + 7.9095e-07*V(FUN_DC)*meta_vsup_max + 7.9095e-07*V(V_SUPPLY)*V(V_SUPPLY) + 7.9095e-07*V(V_SUPPLY)*V(MOST_POS) + -1.03095e-05*V(V_SUPPLY)*V(EN_LDO) + -2.44035e-06*V(V_SUPPLY)*meta_corner + 7.87685e-10*V(V_SUPPLY)*meta_temp + 7.9095e-07*V(V_SUPPLY)*meta_vsup_max + 7.9095e-07*V(MOST_POS)*V(MOST_POS) + -1.03095e-05*V(MOST_POS)*V(EN_LDO) + -2.44035e-06*V(MOST_POS)*meta_corner + 7.87987e-10*V(MOST_POS)*meta_temp + 7.9095e-07*V(MOST_POS)*meta_vsup_max + 5.02118e-05*V(EN_LDO)*V(EN_LDO) + -6.98176e-05*V(EN_LDO)*meta_corner + 2.11772e-07*V(EN_LDO)*meta_temp + -1.03095e-05*V(EN_LDO)*meta_vsup_max + -0.000223189*meta_corner*meta_corner + 2.61791e-07*meta_corner*meta_temp + -2.44035e-06*meta_corner*meta_vsup_max + -9.02329e-10*meta_temp*meta_temp + 7.87681e-10*meta_temp*meta_vsup_max + 7.9095e-07*meta_vsup_max*meta_vsup_max + -0.000164158*ddt(V(VREF)) + -0.00264482*ddt(V(FUN_DC)) + -0.00264482*ddt(V(V_SUPPLY)) + -0.00264482*ddt(V(MOST_POS)) + 0.00201617*idt(V(VPWR)) + -0.0031892*idt(V(VREF)) + -0.000691935*idt(V(FUN_DC)) + -0.000691935*idt(V(V_SUPPLY)) + -0.000691935*idt(V(MOST_POS)) + 0.000682374*idt(V(EN_LDO)) + 8.55812e-05;  // V_SUPPLY_I
            end
            REGULATION_2: begin
                I(FUN_DC, GND) <+ -2.29602*V(VPWR) + 9.95411e-05*V(VREF) + 0.000674366*V(FUN_DC) + 0.764694*V(V_SUPPLY) + 0.764694*V(MOST_POS) + 0.000710467*V(EN_LDO) + -0.00143099*meta_corner + -6.08277e-06*meta_temp + 0.764694*meta_vsup_max + 3.63969*V(VPWR)*V(VPWR) + -1.60721*V(VPWR)*V(VREF) + 1.82498*V(VPWR)*V(FUN_DC) + 1.21493*V(VPWR)*V(V_SUPPLY) + 1.21493*V(VPWR)*V(MOST_POS) + -11.4801*V(VPWR)*V(EN_LDO) + 9.22976*V(VPWR)*meta_corner + -0.00931148*V(VPWR)*meta_temp + 1.21493*V(VPWR)*meta_vsup_max + 6.96296e-05*V(VREF)*V(VREF) + 0.000471978*V(VREF)*V(FUN_DC) + 0.535286*V(VREF)*V(V_SUPPLY) + 0.535286*V(VREF)*V(MOST_POS) + 0.00049733*V(VREF)*V(EN_LDO) + -0.00100169*V(VREF)*meta_corner + -4.24702e-06*V(VREF)*meta_temp + 0.535286*V(VREF)*meta_vsup_max + -0.00974173*V(FUN_DC)*V(FUN_DC) + -0.604019*V(FUN_DC)*V(V_SUPPLY) + -0.604019*V(FUN_DC)*V(MOST_POS) + 0.00337114*V(FUN_DC)*V(EN_LDO) + 0.0202686*V(FUN_DC)*meta_corner + -3.91834e-05*V(FUN_DC)*meta_temp + -0.604019*V(FUN_DC)*meta_vsup_max + -1.21407*V(V_SUPPLY)*V(V_SUPPLY) + -1.21407*V(V_SUPPLY)*V(MOST_POS) + 3.82347*V(V_SUPPLY)*V(EN_LDO) + -3.08147*V(V_SUPPLY)*meta_corner + 0.00312374*V(V_SUPPLY)*meta_temp + -1.21407*V(V_SUPPLY)*meta_vsup_max + -1.21407*V(MOST_POS)*V(MOST_POS) + 3.82347*V(MOST_POS)*V(EN_LDO) + -3.08147*V(MOST_POS)*meta_corner + 0.00312367*V(MOST_POS)*meta_temp + -1.21407*V(MOST_POS)*meta_vsup_max + 0.00355251*V(EN_LDO)*V(EN_LDO) + -0.00715496*V(EN_LDO)*meta_corner + -3.0158e-05*V(EN_LDO)*meta_temp + 3.82347*V(EN_LDO)*meta_vsup_max + -0.0458361*meta_corner*meta_corner + -0.000150469*meta_corner*meta_temp + -3.08147*meta_corner*meta_vsup_max + 3.50519e-07*meta_temp*meta_temp + 0.00312375*meta_temp*meta_vsup_max + -1.21407*meta_vsup_max*meta_vsup_max + -3.28822e-09*ddt(V(VPWR)) + -96.5456*ddt(V(VREF)) + 1.89603e-08*ddt(V(FUN_DC)) + 2.96175*ddt(V(V_SUPPLY)) + 2.96175*ddt(V(MOST_POS)) + -3.85824*ddt(V(EN_LDO)) + 0.29929*idt(V(VPWR)) + -0.00136598*idt(V(VREF)) + -2.0381*idt(V(FUN_DC)) + 0.888004*idt(V(V_SUPPLY)) + 0.888004*idt(V(MOST_POS)) + -0.00969586*idt(V(EN_LDO)) + 0.000142098;  // FUN_DC_I
                I(MOST_POS, GND) <+ -0.177498*V(VPWR) + 5.68225e-06*V(VREF) + -0.000376988*V(FUN_DC) + 0.0592777*V(V_SUPPLY) + 0.0592778*V(MOST_POS) + 4.05176e-05*V(EN_LDO) + -0.000153403*meta_corner + 7.59129e-07*meta_temp + 0.0592777*meta_vsup_max + 0.0819587*V(VPWR)*V(VPWR) + -0.124249*V(VPWR)*V(VREF) + 0.038813*V(VPWR)*V(FUN_DC) + 0.0271446*V(VPWR)*V(V_SUPPLY) + 0.0271446*V(VPWR)*V(MOST_POS) + -0.887492*V(VPWR)*V(EN_LDO) + -1.38243*V(VPWR)*meta_corner + 0.00564544*V(VPWR)*meta_temp + 0.0271446*V(VPWR)*meta_vsup_max + 3.97122e-06*V(VREF)*V(VREF) + -0.000263901*V(VREF)*V(FUN_DC) + 0.0414944*V(VREF)*V(V_SUPPLY) + 0.0414944*V(VREF)*V(MOST_POS) + 2.83628e-05*V(VREF)*V(EN_LDO) + -0.000107382*V(VREF)*meta_corner + 5.32807e-07*V(VREF)*meta_temp + 0.0414944*V(VREF)*meta_vsup_max + 0.00579917*V(FUN_DC)*V(FUN_DC) + -0.0153037*V(FUN_DC)*V(V_SUPPLY) + -0.0153037*V(FUN_DC)*V(MOST_POS) + -0.00188503*V(FUN_DC)*V(EN_LDO) + -0.000723442*V(FUN_DC)*meta_corner + 4.97961e-06*V(FUN_DC)*meta_temp + -0.0153037*V(FUN_DC)*meta_vsup_max + -0.0269722*V(V_SUPPLY)*V(V_SUPPLY) + -0.0269722*V(V_SUPPLY)*V(MOST_POS) + 0.296389*V(V_SUPPLY)*V(EN_LDO) + 0.460528*V(V_SUPPLY)*meta_corner + -0.00188264*V(V_SUPPLY)*meta_temp + -0.0269722*V(V_SUPPLY)*meta_vsup_max + -0.0269722*V(MOST_POS)*V(MOST_POS) + 0.296389*V(MOST_POS)*V(EN_LDO) + 0.460528*V(MOST_POS)*meta_corner + -0.00188265*V(MOST_POS)*meta_temp + -0.0269722*V(MOST_POS)*meta_vsup_max + 0.000202611*V(EN_LDO)*V(EN_LDO) + -0.000767013*V(EN_LDO)*meta_corner + 3.82863e-06*V(EN_LDO)*meta_temp + 0.296389*V(EN_LDO)*meta_vsup_max + -0.031758*meta_corner*meta_corner + 5.92546e-05*meta_corner*meta_temp + 0.460528*meta_corner*meta_vsup_max + -2.07153e-07*meta_temp*meta_temp + -0.00188264*meta_temp*meta_vsup_max + -0.0269722*meta_vsup_max*meta_vsup_max + 6.04364e-09*ddt(V(VPWR)) + -12.4547*ddt(V(VREF)) + 3.19539e-08*ddt(V(FUN_DC)) + 4.42795*ddt(V(V_SUPPLY)) + 4.42795*ddt(V(MOST_POS)) + -5.14689*ddt(V(EN_LDO)) + -0.5378*idt(V(VPWR)) + 0.00189536*idt(V(VREF)) + 1.16298*idt(V(FUN_DC)) + -0.336535*idt(V(V_SUPPLY)) + -0.336535*idt(V(MOST_POS)) + 0.0135456*idt(V(EN_LDO)) + 8.10413e-06;  // MOST_POS_I
                V(VDD_1V2) <+ 4.52888*V(VPWR) + -0.000447107*V(VREF) + 0.0170408*V(FUN_DC) + -1.51215*V(V_SUPPLY) + -1.51214*V(MOST_POS) + -0.00321471*V(EN_LDO) + 0.136888*meta_corner + 0.000197202*meta_temp + -1.51215*meta_vsup_max + -12.7373*V(VPWR)*V(VPWR) + 3.17021*V(VPWR)*V(VREF) + -6.66712*V(VPWR)*V(FUN_DC) + -4.48704*V(VPWR)*V(V_SUPPLY) + -4.48704*V(VPWR)*V(MOST_POS) + 22.6444*V(VPWR)*V(EN_LDO) + -781.456*V(VPWR)*meta_corner + -0.0538156*V(VPWR)*meta_temp + -4.48704*V(VPWR)*meta_vsup_max + -0.000314888*V(VREF)*V(VREF) + 0.0119255*V(VREF)*V(FUN_DC) + -1.0585*V(VREF)*V(V_SUPPLY) + -1.0585*V(VREF)*V(MOST_POS) + -0.00225015*V(VREF)*V(EN_LDO) + 0.0958216*V(VREF)*meta_corner + 0.000138486*V(VREF)*meta_temp + -1.0585*V(VREF)*meta_vsup_max + -0.0388314*V(FUN_DC)*V(FUN_DC) + 2.20123*V(FUN_DC)*V(V_SUPPLY) + 2.20123*V(FUN_DC)*V(MOST_POS) + 0.0851765*V(FUN_DC)*V(EN_LDO) + -1.49692*V(FUN_DC)*meta_corner + -0.000149828*V(FUN_DC)*meta_temp + 2.20123*V(FUN_DC)*meta_vsup_max + 4.38131*V(V_SUPPLY)*V(V_SUPPLY) + 4.38131*V(V_SUPPLY)*V(MOST_POS) + -7.56076*V(V_SUPPLY)*V(EN_LDO) + 261.034*V(V_SUPPLY)*meta_corner + 0.017758*V(V_SUPPLY)*meta_temp + 4.38131*V(V_SUPPLY)*meta_vsup_max + 4.38131*V(MOST_POS)*V(MOST_POS) + -7.56076*V(MOST_POS)*V(EN_LDO) + 261.034*V(MOST_POS)*meta_corner + 0.0177551*V(MOST_POS)*meta_temp + 4.38131*V(MOST_POS)*meta_vsup_max + -0.0160664*V(EN_LDO)*V(EN_LDO) + 0.68444*V(EN_LDO)*meta_corner + 0.000996209*V(EN_LDO)*meta_temp + -7.56076*V(EN_LDO)*meta_vsup_max + 9.36159*meta_corner*meta_corner + 0.00336005*meta_corner*meta_temp + 261.034*meta_corner*meta_vsup_max + -6.16695e-06*meta_temp*meta_temp + 0.0177585*meta_temp*meta_vsup_max + 4.38131*meta_vsup_max*meta_vsup_max + 3.46804e-07*ddt(V(VPWR)) + -3824.25*ddt(V(VREF)) + 1.53614e-07*ddt(V(FUN_DC)) + 75.4004*ddt(V(V_SUPPLY)) + 75.4004*ddt(V(MOST_POS)) + 411.789*ddt(V(EN_LDO)) + 79.7527*idt(V(VPWR)) + -0.151713*idt(V(VREF)) + 4.67315*idt(V(FUN_DC)) + -41.7099*idt(V(V_SUPPLY)) + -41.7099*idt(V(MOST_POS)) + -1.08123*idt(V(EN_LDO)) + -0.000642754;
                I(VPWR, GND) <+ -1.47227*V(VPWR) + 2.94205e-05*V(VREF) + -0.000112054*V(FUN_DC) + 0.490662*V(V_SUPPLY) + 0.490662*V(MOST_POS) + 0.000210103*V(EN_LDO) + -0.000820334*meta_corner + 1.63368e-08*meta_temp + 0.490662*meta_vsup_max + 1.78207*V(VPWR)*V(VPWR) + -1.03059*V(VPWR)*V(VREF) + 0.894483*V(VPWR)*V(FUN_DC) + 0.597702*V(VPWR)*V(V_SUPPLY) + 0.597702*V(VPWR)*V(MOST_POS) + -7.36134*V(VPWR)*V(EN_LDO) + 4.20706*V(VPWR)*meta_corner + 0.0066488*V(VPWR)*meta_temp + 0.597702*V(VPWR)*meta_vsup_max + 2.05904e-05*V(VREF)*V(VREF) + -7.84437e-05*V(VREF)*V(FUN_DC) + 0.343463*V(VREF)*V(V_SUPPLY) + 0.343463*V(VREF)*V(MOST_POS) + 0.000147072*V(VREF)*V(EN_LDO) + -0.000574234*V(VREF)*meta_corner + 1.21524e-08*V(VREF)*meta_temp + 0.343463*V(VREF)*meta_vsup_max + 0.00142716*V(FUN_DC)*V(FUN_DC) + -0.29882*V(FUN_DC)*V(V_SUPPLY) + -0.29882*V(FUN_DC)*V(MOST_POS) + -0.000560323*V(FUN_DC)*V(EN_LDO) + -0.000748611*V(FUN_DC)*meta_corner + 4.69844e-06*V(FUN_DC)*meta_temp + -0.29882*V(FUN_DC)*meta_vsup_max + -0.595601*V(V_SUPPLY)*V(V_SUPPLY) + -0.595601*V(V_SUPPLY)*V(MOST_POS) + 2.45331*V(V_SUPPLY)*V(EN_LDO) + -1.40117*V(V_SUPPLY)*meta_corner + -0.00221764*V(V_SUPPLY)*meta_temp + -0.595601*V(V_SUPPLY)*meta_vsup_max + -0.595601*V(MOST_POS)*V(MOST_POS) + 2.45331*V(MOST_POS)*V(EN_LDO) + -1.40117*V(MOST_POS)*meta_corner + -0.00221765*V(MOST_POS)*meta_temp + -0.595601*V(MOST_POS)*meta_vsup_max + 0.00105053*V(EN_LDO)*V(EN_LDO) + -0.00410167*V(EN_LDO)*meta_corner + 1.01175e-07*V(EN_LDO)*meta_temp + 2.45331*V(EN_LDO)*meta_vsup_max + -0.0249944*meta_corner*meta_corner + -2.77114e-05*meta_corner*meta_temp + -1.40117*meta_corner*meta_vsup_max + 1.23844e-08*meta_temp*meta_temp + -0.00221764*meta_temp*meta_vsup_max + -0.595601*meta_vsup_max*meta_vsup_max + 6.69942e-09*ddt(V(VPWR)) + -7.13142*ddt(V(VREF)) + 2.96623e-08*ddt(V(FUN_DC)) + 0.179014*ddt(V(V_SUPPLY)) + 0.179014*ddt(V(MOST_POS)) + 4.70322*ddt(V(EN_LDO)) + -0.0472972*idt(V(VPWR)) + -0.00261463*idt(V(VREF)) + 1.09741*idt(V(FUN_DC)) + -0.51673*idt(V(V_SUPPLY)) + -0.51673*idt(V(MOST_POS)) + -0.0186709*idt(V(EN_LDO)) + 4.2021e-05;  // VPWR_I
                I(V_SUPPLY, GND) <+ -0.00532258*V(VPWR) + 3.31301e-07*V(VREF) + -6.46907e-06*V(FUN_DC) + 0.00177499*V(V_SUPPLY) + 0.00177499*V(MOST_POS) + 2.3652e-06*V(EN_LDO) + -3.90732e-06*meta_corner + 8.62541e-09*meta_temp + 0.00177499*meta_vsup_max + 0.0016471*V(VPWR)*V(VPWR) + -0.00372581*V(VPWR)*V(VREF) + 0.000791119*V(VPWR)*V(FUN_DC) + 0.000547924*V(VPWR)*V(V_SUPPLY) + 0.000547924*V(VPWR)*V(MOST_POS) + -0.0266129*V(VPWR)*V(EN_LDO) + -0.0575029*V(VPWR)*meta_corner + 0.000223039*V(VPWR)*meta_temp + 0.000547924*V(VPWR)*meta_vsup_max + 2.31798e-07*V(VREF)*V(VREF) + -4.52853e-06*V(VREF)*V(FUN_DC) + 0.00124249*V(VREF)*V(V_SUPPLY) + 0.00124249*V(VREF)*V(MOST_POS) + 1.65565e-06*V(VREF)*V(EN_LDO) + -2.73512e-06*V(VREF)*meta_corner + 6.06338e-09*V(VREF)*meta_temp + 0.00124249*V(VREF)*meta_vsup_max + 9.03032e-05*V(FUN_DC)*V(FUN_DC) + -0.000299913*V(FUN_DC)*V(V_SUPPLY) + -0.000299913*V(FUN_DC)*V(MOST_POS) + -3.23469e-05*V(FUN_DC)*V(EN_LDO) + -1.27147e-05*V(FUN_DC)*meta_corner + 9.54191e-08*V(FUN_DC)*meta_temp + -0.000299913*V(FUN_DC)*meta_vsup_max + -0.000543107*V(V_SUPPLY)*V(V_SUPPLY) + -0.000543107*V(V_SUPPLY)*V(MOST_POS) + 0.00887494*V(V_SUPPLY)*V(EN_LDO) + 0.0191593*V(V_SUPPLY)*meta_corner + -7.4347e-05*V(V_SUPPLY)*meta_temp + -0.000543107*V(V_SUPPLY)*meta_vsup_max + -0.000543107*V(MOST_POS)*V(MOST_POS) + 0.00887494*V(MOST_POS)*V(EN_LDO) + 0.0191593*V(MOST_POS)*meta_corner + -7.43472e-05*V(MOST_POS)*meta_temp + -0.000543107*V(MOST_POS)*meta_vsup_max + 1.18264e-05*V(EN_LDO)*V(EN_LDO) + -1.95366e-05*V(EN_LDO)*meta_corner + 4.37225e-08*V(EN_LDO)*meta_temp + 0.00887494*V(EN_LDO)*meta_vsup_max + -0.000847963*meta_corner*meta_corner + 1.19001e-06*meta_corner*meta_temp + 0.0191593*meta_corner*meta_vsup_max + -4.68258e-09*meta_temp*meta_temp + -7.43469e-05*meta_temp*meta_vsup_max + -0.000543107*meta_vsup_max*meta_vsup_max + -0.221681*ddt(V(VREF)) + 5.63349e-10*ddt(V(FUN_DC)) + 0.0050424*ddt(V(V_SUPPLY)) + 0.0050424*ddt(V(MOST_POS)) + 0.0572571*ddt(V(EN_LDO)) + -0.0051213*idt(V(VPWR)) + 3.85427e-05*idt(V(VREF)) + 0.0208749*idt(V(FUN_DC)) + -0.00820964*idt(V(V_SUPPLY)) + -0.00820964*idt(V(MOST_POS)) + 0.000275448*idt(V(EN_LDO)) + 4.73051e-07;  // V_SUPPLY_I
            end
            REGULATION_3: begin
                I(FUN_DC, GND) <+ 14.4569*V(VPWR) + -0.00217142*V(VREF) + -3.60935*V(FUN_DC) + -3.60935*V(V_SUPPLY) + -3.60935*V(MOST_POS) + -0.0155101*V(EN_LDO) + -0.00851543*meta_corner + 1.22203e-05*meta_temp + -3.60935*meta_vsup_max + -26.4213*V(VPWR)*V(VPWR) + 10.1199*V(VPWR)*V(VREF) + -9.95216*V(VPWR)*V(FUN_DC) + -9.95216*V(VPWR)*V(V_SUPPLY) + -9.95216*V(VPWR)*V(MOST_POS) + 72.2847*V(VPWR)*V(EN_LDO) + -22.0772*V(VPWR)*meta_corner + -0.0731065*V(VPWR)*meta_temp + -9.95216*V(VPWR)*meta_vsup_max + -0.00151999*V(VREF)*V(VREF) + -2.52654*V(VREF)*V(FUN_DC) + -2.52654*V(VREF)*V(V_SUPPLY) + -2.52654*V(VREF)*V(MOST_POS) + -0.0108571*V(VREF)*V(EN_LDO) + -0.0059608*V(VREF)*meta_corner + 8.54975e-06*V(VREF)*meta_temp + -2.52654*V(VREF)*meta_vsup_max + 6.62014*V(FUN_DC)*V(FUN_DC) + 6.62014*V(FUN_DC)*V(V_SUPPLY) + 6.62014*V(FUN_DC)*V(MOST_POS) + -18.0467*V(FUN_DC)*V(EN_LDO) + 5.52341*V(FUN_DC)*meta_corner + 0.0182687*V(FUN_DC)*meta_temp + 6.62014*V(FUN_DC)*meta_vsup_max + 6.62014*V(V_SUPPLY)*V(V_SUPPLY) + 6.62014*V(V_SUPPLY)*V(MOST_POS) + -18.0467*V(V_SUPPLY)*V(EN_LDO) + 5.52341*V(V_SUPPLY)*meta_corner + 0.0182687*V(V_SUPPLY)*meta_temp + 6.62014*V(V_SUPPLY)*meta_vsup_max + 6.62014*V(MOST_POS)*V(MOST_POS) + -18.0467*V(MOST_POS)*V(EN_LDO) + 5.52341*V(MOST_POS)*meta_corner + 0.0182687*V(MOST_POS)*meta_temp + 6.62014*V(MOST_POS)*meta_vsup_max + -0.0775505*V(EN_LDO)*V(EN_LDO) + -0.0425771*V(EN_LDO)*meta_corner + 6.10083e-05*V(EN_LDO)*meta_temp + -18.0467*V(EN_LDO)*meta_vsup_max + -0.360647*meta_corner*meta_corner + 4.48818e-05*meta_corner*meta_temp + 5.52341*meta_corner*meta_vsup_max + -4.11242e-06*meta_temp*meta_temp + 0.0182687*meta_temp*meta_vsup_max + 6.62014*meta_vsup_max*meta_vsup_max + 1.13505e-06*ddt(V(VPWR)) + 43.0312*ddt(V(VREF)) + -0.280518*ddt(V(FUN_DC)) + -0.280518*ddt(V(V_SUPPLY)) + -0.280518*ddt(V(MOST_POS)) + -8.72406*ddt(V(EN_LDO)) + 67.0874*idt(V(VPWR)) + 2.35982*idt(V(VREF)) + -12.6202*idt(V(FUN_DC)) + -33.9945*idt(V(V_SUPPLY)) + -33.9945*idt(V(MOST_POS)) + 16.8557*idt(V(EN_LDO)) + -0.00310202;  // FUN_DC_I
                I(MOST_POS, GND) <+ -0.00231099*V(VPWR) + 5.64783e-07*V(VREF) + 0.000575771*V(FUN_DC) + 0.000575769*V(V_SUPPLY) + 0.000575768*V(MOST_POS) + 4.04912e-06*V(EN_LDO) + -6.1579e-06*meta_corner + 3.95363e-08*meta_temp + 0.000575768*meta_vsup_max + -0.00188735*V(VPWR)*V(VPWR) + -0.00161769*V(VPWR)*V(VREF) + -0.000735225*V(VPWR)*V(FUN_DC) + -0.000735225*V(VPWR)*V(V_SUPPLY) + -0.000735225*V(VPWR)*V(MOST_POS) + -0.011555*V(VPWR)*V(EN_LDO) + -0.00342527*V(VPWR)*meta_corner + -0.000202993*V(VPWR)*meta_temp + -0.000735225*V(VPWR)*meta_vsup_max + 3.96828e-07*V(VREF)*V(VREF) + 0.000403038*V(VREF)*V(FUN_DC) + 0.000403038*V(VREF)*V(V_SUPPLY) + 0.000403038*V(VREF)*V(MOST_POS) + 2.83391e-06*V(VREF)*V(EN_LDO) + -4.31053e-06*V(VREF)*meta_corner + 2.88472e-08*V(VREF)*meta_temp + 0.000403038*V(VREF)*meta_vsup_max + 0.000484836*V(FUN_DC)*V(FUN_DC) + 0.000484836*V(FUN_DC)*V(V_SUPPLY) + 0.000484836*V(FUN_DC)*V(MOST_POS) + 0.00287884*V(FUN_DC)*V(EN_LDO) + 0.000849138*V(FUN_DC)*meta_corner + 5.07094e-05*V(FUN_DC)*meta_temp + 0.000484836*V(FUN_DC)*meta_vsup_max + 0.000484836*V(V_SUPPLY)*V(V_SUPPLY) + 0.000484836*V(V_SUPPLY)*V(MOST_POS) + 0.00287884*V(V_SUPPLY)*V(EN_LDO) + 0.000849138*V(V_SUPPLY)*meta_corner + 5.06942e-05*V(V_SUPPLY)*meta_temp + 0.000484836*V(V_SUPPLY)*meta_vsup_max + 0.000484836*V(MOST_POS)*V(MOST_POS) + 0.00287884*V(MOST_POS)*V(EN_LDO) + 0.000849138*V(MOST_POS)*meta_corner + 5.07089e-05*V(MOST_POS)*meta_temp + 0.000484836*V(MOST_POS)*meta_vsup_max + 2.02345e-05*V(EN_LDO)*V(EN_LDO) + -3.07895e-05*V(EN_LDO)*meta_corner + 2.21719e-07*V(EN_LDO)*meta_temp + 0.00287884*V(EN_LDO)*meta_vsup_max + -0.00130204*meta_corner*meta_corner + -3.38694e-07*meta_corner*meta_temp + 0.000849138*meta_corner*meta_vsup_max + -1.03846e-08*meta_temp*meta_temp + 5.07095e-05*meta_temp*meta_vsup_max + 0.000484836*meta_vsup_max*meta_vsup_max + 1.10035e-09*ddt(V(VPWR)) + -12.6081*ddt(V(VREF)) + 0.0696006*ddt(V(FUN_DC)) + 0.0696006*ddt(V(V_SUPPLY)) + 0.0696006*ddt(V(MOST_POS)) + -0.0853451*ddt(V(EN_LDO)) + 0.0395464*idt(V(VPWR)) + -0.000312111*idt(V(VREF)) + 0.0176686*idt(V(FUN_DC)) + -0.0265309*idt(V(V_SUPPLY)) + -0.0265309*idt(V(MOST_POS)) + -0.00218492*idt(V(EN_LDO)) + 8.09464e-07;  // MOST_POS_I
                V(VDD_1V2) <+ -45.2972*V(VPWR) + 0.00820667*V(VREF) + 11.3039*V(FUN_DC) + 11.3039*V(V_SUPPLY) + 11.3039*V(MOST_POS) + 0.0586202*V(EN_LDO) + 0.111383*meta_corner + 0.000319674*meta_temp + 11.3039*meta_vsup_max + 14.2715*V(VPWR)*V(VPWR) + -31.708*V(VPWR)*V(VREF) + 5.23044*V(VPWR)*V(FUN_DC) + 5.23044*V(VPWR)*V(V_SUPPLY) + 5.23044*V(VPWR)*V(MOST_POS) + -226.486*V(VPWR)*V(EN_LDO) + -1158.91*V(VPWR)*meta_corner + 0.731163*V(VPWR)*meta_temp + 5.23044*V(VPWR)*meta_vsup_max + 0.00574479*V(VREF)*V(VREF) + 7.91271*V(VREF)*V(FUN_DC) + 7.91271*V(VREF)*V(V_SUPPLY) + 7.91271*V(VREF)*V(MOST_POS) + 0.0410341*V(VREF)*V(EN_LDO) + 0.0779678*V(VREF)*meta_corner + 0.000223838*V(VREF)*meta_temp + 7.91271*V(VREF)*meta_vsup_max + -3.49698*V(FUN_DC)*V(FUN_DC) + -3.49698*V(FUN_DC)*V(V_SUPPLY) + -3.49698*V(FUN_DC)*V(MOST_POS) + 56.5194*V(FUN_DC)*V(EN_LDO) + 289.647*V(FUN_DC)*meta_corner + -0.182894*V(FUN_DC)*meta_temp + -3.49698*V(FUN_DC)*meta_vsup_max + -3.49698*V(V_SUPPLY)*V(V_SUPPLY) + -3.49698*V(V_SUPPLY)*V(MOST_POS) + 56.5194*V(V_SUPPLY)*V(EN_LDO) + 289.647*V(V_SUPPLY)*meta_corner + -0.182896*V(V_SUPPLY)*meta_temp + -3.49698*V(V_SUPPLY)*meta_vsup_max + -3.49698*V(MOST_POS)*V(MOST_POS) + 56.5194*V(MOST_POS)*V(EN_LDO) + 289.647*V(MOST_POS)*meta_corner + -0.182895*V(MOST_POS)*meta_temp + -3.49698*V(MOST_POS)*meta_vsup_max + 0.2931*V(EN_LDO)*V(EN_LDO) + 0.556913*V(EN_LDO)*meta_corner + 0.00160067*V(EN_LDO)*meta_temp + 56.5194*V(EN_LDO)*meta_vsup_max + 3.84714*meta_corner*meta_corner + 0.00209573*meta_corner*meta_temp + 289.647*meta_corner*meta_vsup_max + -3.24754e-05*meta_temp*meta_temp + -0.182894*meta_temp*meta_vsup_max + -3.49698*meta_vsup_max*meta_vsup_max + 1.03349e-05*ddt(V(VPWR)) + -1644.23*ddt(V(VREF)) + -17.6654*ddt(V(FUN_DC)) + -17.6654*ddt(V(V_SUPPLY)) + -17.6654*ddt(V(MOST_POS)) + -711.901*ddt(V(EN_LDO)) + 147.018*idt(V(VPWR)) + -2.61717*idt(V(VREF)) + 136.369*idt(V(FUN_DC)) + -142.17*idt(V(V_SUPPLY)) + -142.17*idt(V(MOST_POS)) + -18.6878*idt(V(EN_LDO)) + 0.011724;
                I(VPWR, GND) <+ 1.22764*V(VPWR) + 4.00941e-05*V(VREF) + -0.307005*V(FUN_DC) + -0.307005*V(V_SUPPLY) + -0.307005*V(MOST_POS) + 0.000286472*V(EN_LDO) + 3.99714e-05*meta_corner + -9.77811e-08*meta_temp + -0.307005*meta_vsup_max + 5.61051*V(VPWR)*V(VPWR) + 0.859346*V(VPWR)*V(VREF) + 2.13561*V(VPWR)*V(FUN_DC) + 2.13561*V(VPWR)*V(V_SUPPLY) + 2.13561*V(VPWR)*V(MOST_POS) + 6.13818*V(VPWR)*V(EN_LDO) + 121.987*V(VPWR)*meta_corner + 0.0660039*V(VPWR)*meta_temp + 2.13561*V(VPWR)*meta_vsup_max + 2.80743e-05*V(VREF)*V(VREF) + -0.214904*V(VREF)*V(FUN_DC) + -0.214904*V(VREF)*V(V_SUPPLY) + -0.214904*V(VREF)*V(MOST_POS) + 0.000200531*V(VREF)*V(EN_LDO) + 2.798e-05*V(VREF)*meta_corner + -6.96638e-08*V(VREF)*meta_temp + -0.214904*V(VREF)*meta_vsup_max + -1.41523*V(FUN_DC)*V(FUN_DC) + -1.41523*V(FUN_DC)*V(V_SUPPLY) + -1.41523*V(FUN_DC)*V(MOST_POS) + -1.53503*V(FUN_DC)*V(EN_LDO) + -30.4968*V(FUN_DC)*meta_corner + -0.016501*V(FUN_DC)*meta_temp + -1.41523*V(FUN_DC)*meta_vsup_max + -1.41523*V(V_SUPPLY)*V(V_SUPPLY) + -1.41523*V(V_SUPPLY)*V(MOST_POS) + -1.53503*V(V_SUPPLY)*V(EN_LDO) + -30.4968*V(V_SUPPLY)*meta_corner + -0.016501*V(V_SUPPLY)*meta_temp + -1.41523*V(V_SUPPLY)*meta_vsup_max + -1.41523*V(MOST_POS)*V(MOST_POS) + -1.53503*V(MOST_POS)*V(EN_LDO) + -30.4968*V(MOST_POS)*meta_corner + -0.016501*V(MOST_POS)*meta_temp + -1.41523*V(MOST_POS)*meta_vsup_max + 0.00143237*V(EN_LDO)*V(EN_LDO) + 0.000199857*V(EN_LDO)*meta_corner + -4.99166e-07*V(EN_LDO)*meta_temp + -1.53503*V(EN_LDO)*meta_vsup_max + -0.0106226*meta_corner*meta_corner + -1.58532e-05*meta_corner*meta_temp + -30.4968*meta_corner*meta_vsup_max + 3.67533e-08*meta_temp*meta_temp + -0.016501*meta_temp*meta_vsup_max + -1.41523*meta_vsup_max*meta_vsup_max + 3.81223e-06*ddt(V(VPWR)) + 7.60047*ddt(V(VREF)) + -0.110129*ddt(V(FUN_DC)) + -0.110129*ddt(V(V_SUPPLY)) + -0.110129*ddt(V(MOST_POS)) + -0.423839*ddt(V(EN_LDO)) + -43.3759*idt(V(VPWR)) + -0.0313517*idt(V(VREF)) + -15.4765*idt(V(FUN_DC)) + 29.5234*idt(V(V_SUPPLY)) + 29.5234*idt(V(MOST_POS)) + -0.223971*idt(V(EN_LDO)) + 5.72947e-05;  // VPWR_I
                I(V_SUPPLY, GND) <+ 0.00285059*V(VPWR) + 1.05999e-06*V(VREF) + -0.000714817*V(FUN_DC) + -0.000714817*V(V_SUPPLY) + -0.000714817*V(MOST_POS) + 7.57119e-06*V(EN_LDO) + 3.70949e-06*meta_corner + 4.83822e-09*meta_temp + -0.000714817*meta_vsup_max + 0.004536*V(VPWR)*V(VPWR) + 0.00199541*V(VPWR)*V(VREF) + 0.00174908*V(VPWR)*V(FUN_DC) + 0.00174908*V(VPWR)*V(V_SUPPLY) + 0.00174908*V(VPWR)*V(MOST_POS) + 0.014253*V(VPWR)*V(EN_LDO) + -0.00542868*V(VPWR)*meta_corner + 0.000147118*V(VPWR)*meta_temp + 0.00174908*V(VPWR)*meta_vsup_max + 7.41977e-07*V(VREF)*V(VREF) + -0.000500372*V(VREF)*V(FUN_DC) + -0.000500372*V(VREF)*V(V_SUPPLY) + -0.000500372*V(VREF)*V(MOST_POS) + 5.29984e-06*V(VREF)*V(EN_LDO) + 2.59665e-06*V(VREF)*meta_corner + 3.37984e-09*V(VREF)*meta_temp + -0.000500372*V(VREF)*meta_vsup_max + -0.00115207*V(FUN_DC)*V(FUN_DC) + -0.00115207*V(FUN_DC)*V(V_SUPPLY) + -0.00115207*V(FUN_DC)*V(MOST_POS) + -0.00357409*V(FUN_DC)*V(EN_LDO) + 0.00135485*V(FUN_DC)*meta_corner + -3.67835e-05*V(FUN_DC)*meta_temp + -0.00115207*V(FUN_DC)*meta_vsup_max + -0.00115207*V(V_SUPPLY)*V(V_SUPPLY) + -0.00115207*V(V_SUPPLY)*V(MOST_POS) + -0.00357409*V(V_SUPPLY)*V(EN_LDO) + 0.00135485*V(V_SUPPLY)*meta_corner + -3.67834e-05*V(V_SUPPLY)*meta_temp + -0.00115207*V(V_SUPPLY)*meta_vsup_max + -0.00115207*V(MOST_POS)*V(MOST_POS) + -0.00357409*V(MOST_POS)*V(EN_LDO) + 0.00135485*V(MOST_POS)*meta_corner + -3.67835e-05*V(MOST_POS)*meta_temp + -0.00115207*V(MOST_POS)*meta_vsup_max + 3.7856e-05*V(EN_LDO)*V(EN_LDO) + 1.85475e-05*V(EN_LDO)*meta_corner + 2.4047e-08*V(EN_LDO)*meta_temp + -0.00357409*V(EN_LDO)*meta_vsup_max + 8.82986e-05*meta_corner*meta_corner + 1.23731e-07*meta_corner*meta_temp + 0.00135485*meta_corner*meta_vsup_max + 4.97207e-10*meta_temp*meta_temp + -3.67835e-05*meta_temp*meta_vsup_max + -0.00115207*meta_vsup_max*meta_vsup_max + 9.88798e-10*ddt(V(VPWR)) + 0.0805942*ddt(V(VREF)) + -0.00127848*ddt(V(FUN_DC)) + -0.00127848*ddt(V(V_SUPPLY)) + -0.00127848*ddt(V(MOST_POS)) + 0.00226113*ddt(V(EN_LDO)) + -0.0639341*idt(V(VPWR)) + -0.00115004*idt(V(VREF)) + -0.0244898*idt(V(FUN_DC)) + 0.0475784*idt(V(V_SUPPLY)) + 0.0475784*idt(V(MOST_POS)) + -0.00821486*idt(V(EN_LDO)) + 1.51424e-06;  // V_SUPPLY_I
            end
            REGULATION_4: begin
                I(FUN_DC, GND) <+ -0.0107398*V(VPWR) + 0.00398131*V(VREF) + -0.0107398*V(FUN_DC) + -0.0107398*V(V_SUPPLY) + -0.0107398*V(MOST_POS) + 0.0284377*V(EN_LDO) + 0.0154357*meta_corner + 1.78382e-06*meta_temp + -0.0107398*meta_vsup_max + 0.0092912*V(VPWR)*V(VPWR) + -0.00751786*V(VPWR)*V(VREF) + 0.0092912*V(VPWR)*V(FUN_DC) + 0.0092912*V(VPWR)*V(V_SUPPLY) + 0.0092912*V(VPWR)*V(MOST_POS) + -0.053699*V(VPWR)*V(EN_LDO) + -0.0156043*V(VPWR)*meta_corner + 3.81693e-05*V(VPWR)*meta_temp + 0.0092912*V(VPWR)*meta_vsup_max + 0.00278689*V(VREF)*V(VREF) + -0.00751786*V(VREF)*V(FUN_DC) + -0.00751786*V(VREF)*V(V_SUPPLY) + -0.00751786*V(VREF)*V(MOST_POS) + 0.0199064*V(VREF)*V(EN_LDO) + 0.010805*V(VREF)*meta_corner + 1.22716e-06*V(VREF)*meta_temp + -0.00751786*V(VREF)*meta_vsup_max + 0.0092912*V(FUN_DC)*V(FUN_DC) + 0.0092912*V(FUN_DC)*V(V_SUPPLY) + 0.0092912*V(FUN_DC)*V(MOST_POS) + -0.053699*V(FUN_DC)*V(EN_LDO) + -0.0156043*V(FUN_DC)*meta_corner + 3.81689e-05*V(FUN_DC)*meta_temp + 0.0092912*V(FUN_DC)*meta_vsup_max + 0.0092912*V(V_SUPPLY)*V(V_SUPPLY) + 0.0092912*V(V_SUPPLY)*V(MOST_POS) + -0.053699*V(V_SUPPLY)*V(EN_LDO) + -0.0156043*V(V_SUPPLY)*meta_corner + 3.75241e-05*V(V_SUPPLY)*meta_temp + 0.0092912*V(V_SUPPLY)*meta_vsup_max + 0.0092912*V(MOST_POS)*V(MOST_POS) + -0.053699*V(MOST_POS)*V(EN_LDO) + -0.0156043*V(MOST_POS)*meta_corner + 3.81678e-05*V(MOST_POS)*meta_temp + 0.0092912*V(MOST_POS)*meta_vsup_max + 0.142188*V(EN_LDO)*V(EN_LDO) + 0.0771785*V(EN_LDO)*meta_corner + 8.69175e-06*V(EN_LDO)*meta_temp + -0.053699*V(EN_LDO)*meta_vsup_max + -0.272674*meta_corner*meta_corner + 0.00045839*meta_corner*meta_temp + -0.0156043*meta_corner*meta_vsup_max + -8.30785e-06*meta_temp*meta_temp + 3.81641e-05*meta_temp*meta_vsup_max + 0.0092912*meta_vsup_max*meta_vsup_max + 1.50655*ddt(V(VPWR)) + 50.4376*ddt(V(VREF)) + 1.50655*ddt(V(FUN_DC)) + 1.50655*ddt(V(V_SUPPLY)) + 1.50655*ddt(V(MOST_POS)) + -14.4368*ddt(V(EN_LDO)) + 0.336786*idt(V(VPWR)) + -0.252008*idt(V(VREF)) + 0.336786*idt(V(FUN_DC)) + 0.336786*idt(V(V_SUPPLY)) + 0.336786*idt(V(MOST_POS)) + -1.80007*idt(V(EN_LDO)) + 0.00568754;  // FUN_DC_I
                I(MOST_POS, GND) <+ -1.07523e-05*V(VPWR) + 3.55336e-06*V(VREF) + -1.07524e-05*V(FUN_DC) + -1.07523e-05*V(V_SUPPLY) + -1.07523e-05*V(MOST_POS) + 2.53721e-05*V(EN_LDO) + -4.78853e-06*meta_corner + 4.6643e-08*meta_temp + -1.07523e-05*meta_vsup_max + 1.03916e-05*V(VPWR)*V(VPWR) + -7.52662e-06*V(VPWR)*V(VREF) + 1.03916e-05*V(VPWR)*V(FUN_DC) + 1.03916e-05*V(VPWR)*V(V_SUPPLY) + 1.03916e-05*V(VPWR)*V(MOST_POS) + -5.37616e-05*V(VPWR)*V(EN_LDO) + -1.13186e-06*V(VPWR)*meta_corner + -1.02823e-08*V(VPWR)*meta_temp + 1.03916e-05*V(VPWR)*meta_vsup_max + 2.48647e-06*V(VREF)*V(VREF) + -7.52662e-06*V(VREF)*V(FUN_DC) + -7.52662e-06*V(VREF)*V(V_SUPPLY) + -7.52662e-06*V(VREF)*V(MOST_POS) + 1.77605e-05*V(VREF)*V(EN_LDO) + -3.35197e-06*V(VREF)*meta_corner + 3.17859e-08*V(VREF)*meta_temp + -7.52662e-06*V(VREF)*meta_vsup_max + 1.03916e-05*V(FUN_DC)*V(FUN_DC) + 1.03916e-05*V(FUN_DC)*V(V_SUPPLY) + 1.03916e-05*V(FUN_DC)*V(MOST_POS) + -5.37616e-05*V(FUN_DC)*V(EN_LDO) + -1.13186e-06*V(FUN_DC)*meta_corner + -1.0297e-08*V(FUN_DC)*meta_temp + 1.03916e-05*V(FUN_DC)*meta_vsup_max + 1.03916e-05*V(V_SUPPLY)*V(V_SUPPLY) + 1.03916e-05*V(V_SUPPLY)*V(MOST_POS) + -5.37616e-05*V(V_SUPPLY)*V(EN_LDO) + -1.13186e-06*V(V_SUPPLY)*meta_corner + -3.59257e-08*V(V_SUPPLY)*meta_temp + 1.03916e-05*V(V_SUPPLY)*meta_vsup_max + 1.03916e-05*V(MOST_POS)*V(MOST_POS) + -5.37616e-05*V(MOST_POS)*V(EN_LDO) + -1.13186e-06*V(MOST_POS)*meta_corner + -1.03468e-08*V(MOST_POS)*meta_temp + 1.03916e-05*V(MOST_POS)*meta_vsup_max + 0.000126861*V(EN_LDO)*V(EN_LDO) + -2.39426e-05*V(EN_LDO)*meta_corner + 2.24139e-07*V(EN_LDO)*meta_temp + -5.37616e-05*V(EN_LDO)*meta_vsup_max + -0.000909685*meta_corner*meta_corner + 2.0107e-07*meta_corner*meta_temp + -1.13171e-06*meta_corner*meta_vsup_max + -1.41432e-08*meta_temp*meta_temp + -1.05136e-08*meta_temp*meta_vsup_max + 1.03916e-05*meta_vsup_max*meta_vsup_max + -0.427524*ddt(V(VPWR)) + 2.21196*ddt(V(VREF)) + -0.427524*ddt(V(FUN_DC)) + -0.427524*ddt(V(V_SUPPLY)) + -0.427524*ddt(V(MOST_POS)) + -0.364138*ddt(V(EN_LDO)) + -0.000539673*idt(V(VPWR)) + 0.000278684*idt(V(VREF)) + -0.000539673*idt(V(FUN_DC)) + -0.000539673*idt(V(V_SUPPLY)) + -0.000539673*idt(V(MOST_POS)) + 0.00198992*idt(V(EN_LDO)) + 5.07443e-06;  // MOST_POS_I
                V(VDD_1V2) <+ -0.00388882*V(VPWR) + 0.000813229*V(VREF) + -0.00388877*V(FUN_DC) + -0.0038888*V(V_SUPPLY) + -0.00388881*V(MOST_POS) + 0.0058142*V(EN_LDO) + 0.140852*meta_corner + 0.000542773*meta_temp + -0.00388881*meta_vsup_max + 0.00574139*V(VPWR)*V(VPWR) + -0.00272217*V(VPWR)*V(VREF) + 0.00574139*V(VPWR)*V(FUN_DC) + 0.00574139*V(VPWR)*V(V_SUPPLY) + 0.00574139*V(VPWR)*V(MOST_POS) + -0.0194441*V(VPWR)*V(EN_LDO) + -0.0860062*V(VPWR)*meta_corner + -0.000285072*V(VPWR)*meta_temp + 0.00574139*V(VPWR)*meta_vsup_max + 0.000569791*V(VREF)*V(VREF) + -0.00272217*V(VREF)*V(FUN_DC) + -0.00272217*V(VREF)*V(V_SUPPLY) + -0.00272217*V(VREF)*V(MOST_POS) + 0.00406994*V(VREF)*V(EN_LDO) + 0.0985964*V(VREF)*meta_corner + 0.000380467*V(VREF)*meta_temp + -0.00272217*V(VREF)*meta_vsup_max + 0.00574139*V(FUN_DC)*V(FUN_DC) + 0.00574139*V(FUN_DC)*V(V_SUPPLY) + 0.00574139*V(FUN_DC)*V(MOST_POS) + -0.0194441*V(FUN_DC)*V(EN_LDO) + -0.0860062*V(FUN_DC)*meta_corner + -0.000285063*V(FUN_DC)*meta_temp + 0.00574139*V(FUN_DC)*meta_vsup_max + 0.00574139*V(V_SUPPLY)*V(V_SUPPLY) + 0.00574139*V(V_SUPPLY)*V(MOST_POS) + -0.0194441*V(V_SUPPLY)*V(EN_LDO) + -0.0860062*V(V_SUPPLY)*meta_corner + -0.000269376*V(V_SUPPLY)*meta_temp + 0.00574139*V(V_SUPPLY)*meta_vsup_max + 0.00574139*V(MOST_POS)*V(MOST_POS) + -0.0194441*V(MOST_POS)*V(EN_LDO) + -0.0860062*V(MOST_POS)*meta_corner + -0.000285033*V(MOST_POS)*meta_temp + 0.00574139*V(MOST_POS)*meta_vsup_max + 0.029071*V(EN_LDO)*V(EN_LDO) + 0.70426*V(EN_LDO)*meta_corner + 0.00271942*V(EN_LDO)*meta_temp + -0.0194441*V(EN_LDO)*meta_vsup_max + 3.98612*meta_corner*meta_corner + 0.00430115*meta_corner*meta_temp + -0.0860063*meta_corner*meta_vsup_max + -1.70588e-05*meta_temp*meta_temp + -0.000284938*meta_temp*meta_vsup_max + 0.00574139*meta_vsup_max*meta_vsup_max + -42.8853*ddt(V(VPWR)) + -1323.32*ddt(V(VREF)) + -42.8853*ddt(V(FUN_DC)) + -42.8853*ddt(V(V_SUPPLY)) + -42.8853*ddt(V(MOST_POS)) + 169.96*ddt(V(EN_LDO)) + -2.79183*idt(V(VPWR)) + 1.78411*idt(V(VREF)) + -2.79183*idt(V(FUN_DC)) + -2.79183*idt(V(V_SUPPLY)) + -2.79183*idt(V(MOST_POS)) + 12.7441*idt(V(EN_LDO)) + 0.00116284;
                I(VPWR, GND) <+ 8.0317e-07*V(VPWR) + -2.7485e-07*V(VREF) + 8.03169e-07*V(FUN_DC) + 8.03169e-07*V(V_SUPPLY) + 8.03169e-07*V(MOST_POS) + -1.96328e-06*V(EN_LDO) + -2.03748e-06*meta_corner + -9.13699e-10*meta_temp + 8.0317e-07*meta_vsup_max + -7.28488e-07*V(VPWR)*V(VPWR) + 5.62219e-07*V(VPWR)*V(VREF) + -7.28488e-07*V(VPWR)*V(FUN_DC) + -7.28488e-07*V(VPWR)*V(V_SUPPLY) + -7.28488e-07*V(VPWR)*V(MOST_POS) + 4.01585e-06*V(VPWR)*V(EN_LDO) + 1.62392e-06*V(VPWR)*meta_corner + -5.37176e-09*V(VPWR)*meta_temp + -7.28488e-07*V(VPWR)*meta_vsup_max + -1.92401e-07*V(VREF)*V(VREF) + 5.62219e-07*V(VREF)*V(FUN_DC) + 5.62219e-07*V(VREF)*V(V_SUPPLY) + 5.62219e-07*V(VREF)*V(MOST_POS) + -1.37429e-06*V(VREF)*V(EN_LDO) + -1.42623e-06*V(VREF)*meta_corner + -6.45632e-10*V(VREF)*meta_temp + 5.62219e-07*V(VREF)*meta_vsup_max + -7.28488e-07*V(FUN_DC)*V(FUN_DC) + -7.28488e-07*V(FUN_DC)*V(V_SUPPLY) + -7.28488e-07*V(FUN_DC)*V(MOST_POS) + 4.01585e-06*V(FUN_DC)*V(EN_LDO) + 1.62392e-06*V(FUN_DC)*meta_corner + -5.37186e-09*V(FUN_DC)*meta_temp + -7.28488e-07*V(FUN_DC)*meta_vsup_max + -7.28488e-07*V(V_SUPPLY)*V(V_SUPPLY) + -7.28488e-07*V(V_SUPPLY)*V(MOST_POS) + 4.01585e-06*V(V_SUPPLY)*V(EN_LDO) + 1.62392e-06*V(V_SUPPLY)*meta_corner + -5.55184e-09*V(V_SUPPLY)*meta_temp + -7.28488e-07*V(V_SUPPLY)*meta_vsup_max + -7.28488e-07*V(MOST_POS)*V(MOST_POS) + 4.01585e-06*V(MOST_POS)*V(EN_LDO) + 1.62392e-06*V(MOST_POS)*meta_corner + -5.37219e-09*V(MOST_POS)*meta_temp + -7.28488e-07*V(MOST_POS)*meta_vsup_max + -9.81638e-06*V(EN_LDO)*V(EN_LDO) + -1.01874e-05*V(EN_LDO)*meta_corner + -4.63215e-09*V(EN_LDO)*meta_temp + 4.01585e-06*V(EN_LDO)*meta_vsup_max + -5.17388e-05*meta_corner*meta_corner + -2.06973e-07*meta_corner*meta_temp + 1.62392e-06*meta_corner*meta_vsup_max + 1.74968e-09*meta_temp*meta_temp + -5.3733e-09*meta_temp*meta_vsup_max + -7.28488e-07*meta_vsup_max*meta_vsup_max + -0.0010359*ddt(V(VPWR)) + 0.014998*ddt(V(VREF)) + -0.0010359*ddt(V(FUN_DC)) + -0.0010359*ddt(V(V_SUPPLY)) + -0.0010359*ddt(V(MOST_POS)) + -0.00284436*ddt(V(EN_LDO)) + 2.78823e-05*idt(V(VPWR)) + -1.4911e-05*idt(V(VREF)) + 2.78823e-05*idt(V(FUN_DC)) + 2.78823e-05*idt(V(V_SUPPLY)) + 2.78823e-05*idt(V(MOST_POS)) + -0.000106512*idt(V(EN_LDO)) + -3.92655e-07;  // VPWR_I
                I(V_SUPPLY, GND) <+ -1.33454e-07*V(VPWR) + 4.75468e-08*V(VREF) + -1.33454e-07*V(FUN_DC) + -1.33454e-07*V(V_SUPPLY) + -1.33454e-07*V(MOST_POS) + 3.39607e-07*V(EN_LDO) + 9.9108e-08*meta_corner + -8.5892e-09*meta_temp + -1.33454e-07*meta_vsup_max + 1.08537e-07*V(VPWR)*V(VPWR) + -9.34179e-08*V(VPWR)*V(VREF) + 1.08537e-07*V(VPWR)*V(FUN_DC) + 1.08537e-07*V(VPWR)*V(V_SUPPLY) + 1.08537e-07*V(VPWR)*V(MOST_POS) + -6.67271e-07*V(VPWR)*V(EN_LDO) + 1.64209e-07*V(VPWR)*meta_corner + 9.05203e-09*V(VPWR)*meta_temp + 1.08537e-07*V(VPWR)*meta_vsup_max + 3.32815e-08*V(VREF)*V(VREF) + -9.34179e-08*V(VREF)*V(FUN_DC) + -9.34179e-08*V(VREF)*V(V_SUPPLY) + -9.34179e-08*V(VREF)*V(MOST_POS) + 2.37725e-07*V(VREF)*V(EN_LDO) + 6.93756e-08*V(VREF)*meta_corner + -6.01376e-09*V(VREF)*meta_temp + -9.34179e-08*V(VREF)*meta_vsup_max + 1.08537e-07*V(FUN_DC)*V(FUN_DC) + 1.08537e-07*V(FUN_DC)*V(V_SUPPLY) + 1.08537e-07*V(FUN_DC)*V(MOST_POS) + -6.67271e-07*V(FUN_DC)*V(EN_LDO) + 1.64209e-07*V(FUN_DC)*meta_corner + 9.05201e-09*V(FUN_DC)*meta_temp + 1.08537e-07*V(FUN_DC)*meta_vsup_max + 1.08537e-07*V(V_SUPPLY)*V(V_SUPPLY) + 1.08537e-07*V(V_SUPPLY)*V(MOST_POS) + -6.67271e-07*V(V_SUPPLY)*V(EN_LDO) + 1.64209e-07*V(V_SUPPLY)*meta_corner + 9.01252e-09*V(V_SUPPLY)*meta_temp + 1.08537e-07*V(V_SUPPLY)*meta_vsup_max + 1.08537e-07*V(MOST_POS)*V(MOST_POS) + -6.67271e-07*V(MOST_POS)*V(EN_LDO) + 1.64209e-07*V(MOST_POS)*meta_corner + 9.05194e-09*V(MOST_POS)*meta_temp + 1.08537e-07*V(MOST_POS)*meta_vsup_max + 1.69804e-06*V(EN_LDO)*V(EN_LDO) + 4.9554e-07*V(EN_LDO)*meta_corner + -4.29599e-08*V(EN_LDO)*meta_temp + -6.67271e-07*V(EN_LDO)*meta_vsup_max + 1.62552e-05*meta_corner*meta_corner + 4.05772e-08*meta_corner*meta_temp + 1.64209e-07*meta_corner*meta_vsup_max + 4.48377e-10*meta_temp*meta_temp + 9.05171e-09*meta_temp*meta_vsup_max + 1.08537e-07*meta_vsup_max*meta_vsup_max + -9.91736e-06*ddt(V(VPWR)) + 0.00313824*ddt(V(VREF)) + -9.91736e-06*ddt(V(FUN_DC)) + -9.91736e-06*ddt(V(V_SUPPLY)) + -9.91736e-06*ddt(V(MOST_POS)) + -0.000829025*ddt(V(EN_LDO)) + 2.73566e-05*idt(V(VPWR)) + -1.27794e-05*idt(V(VREF)) + 2.73566e-05*idt(V(FUN_DC)) + 2.73566e-05*idt(V(V_SUPPLY)) + 2.73566e-05*idt(V(MOST_POS)) + -9.12823e-05*idt(V(EN_LDO)) + 6.79214e-08;  // V_SUPPLY_I
            end
            REGULATION_5: begin
                I(FUN_DC, GND) <+ 3.27053e-05*V(VPWR) + -0.00026451*V(VREF) + 3.41876e-05*V(FUN_DC) + 3.41876e-05*V(V_SUPPLY) + 3.41876e-05*V(MOST_POS) + 1.53089e-05*V(EN_LDO) + 4.1895e-05*meta_corner + 4.05621e-08*meta_temp + 3.41876e-05*meta_vsup_max + -1.0039e-06*V(VPWR)*V(VPWR) + 2.28937e-05*V(VPWR)*V(VREF) + -4.76645e-07*V(VPWR)*V(FUN_DC) + -4.76645e-07*V(VPWR)*V(V_SUPPLY) + -4.76645e-07*V(VPWR)*V(MOST_POS) + -6.17811e-06*V(VPWR)*V(EN_LDO) + -6.12097e-06*V(VPWR)*meta_corner + 6.70132e-09*V(VPWR)*meta_temp + -4.76645e-07*V(VPWR)*meta_vsup_max + -0.000185157*V(VREF)*V(VREF) + 2.39314e-05*V(VREF)*V(FUN_DC) + 2.39314e-05*V(VREF)*V(V_SUPPLY) + 2.39314e-05*V(VREF)*V(MOST_POS) + 1.07162e-05*V(VREF)*V(EN_LDO) + 2.93265e-05*V(VREF)*meta_corner + 2.83935e-08*V(VREF)*meta_temp + 2.39314e-05*V(VREF)*meta_vsup_max + -2.23129e-06*V(FUN_DC)*V(FUN_DC) + -2.23129e-06*V(FUN_DC)*V(V_SUPPLY) + -2.23129e-06*V(FUN_DC)*V(MOST_POS) + 1.23362e-06*V(FUN_DC)*V(EN_LDO) + -1.40785e-06*V(FUN_DC)*meta_corner + -6.0496e-09*V(FUN_DC)*meta_temp + -2.23129e-06*V(FUN_DC)*meta_vsup_max + -2.23129e-06*V(V_SUPPLY)*V(V_SUPPLY) + -2.23129e-06*V(V_SUPPLY)*V(MOST_POS) + 1.23362e-06*V(V_SUPPLY)*V(EN_LDO) + -1.40785e-06*V(V_SUPPLY)*meta_corner + -6.04956e-09*V(V_SUPPLY)*meta_temp + -2.23129e-06*V(V_SUPPLY)*meta_vsup_max + -2.23129e-06*V(MOST_POS)*V(MOST_POS) + 1.23362e-06*V(MOST_POS)*V(EN_LDO) + -1.40785e-06*V(MOST_POS)*meta_corner + -6.04962e-09*V(MOST_POS)*meta_temp + -2.23129e-06*V(MOST_POS)*meta_vsup_max + -2.12103e-06*V(EN_LDO)*V(EN_LDO) + 1.96919e-06*V(EN_LDO)*meta_corner + -8.5784e-10*V(EN_LDO)*meta_temp + 1.23362e-06*V(EN_LDO)*meta_vsup_max + 5.45536e-05*meta_corner*meta_corner + 3.02903e-08*meta_corner*meta_temp + -1.40785e-06*meta_corner*meta_vsup_max + 5.34797e-10*meta_temp*meta_temp + -6.04962e-09*meta_temp*meta_vsup_max + -2.23129e-06*meta_vsup_max*meta_vsup_max + 3.45115e-05*ddt(V(VREF)) + 0.000550796*ddt(V(FUN_DC)) + 0.000550796*ddt(V(V_SUPPLY)) + 0.000550796*ddt(V(MOST_POS)) + -0.000911712*idt(V(VPWR)) + 9.1771e-05*idt(V(VREF)) + 0.00023083*idt(V(FUN_DC)) + 0.000393988*idt(V(V_SUPPLY)) + 0.000393988*idt(V(MOST_POS)) + -0.000219704*idt(V(EN_LDO)) + -0.000377872;  // FUN_DC_I
                I(MOST_POS, GND) <+ 5.85564e-05*V(VPWR) + -0.00174834*V(VREF) + 6.05135e-05*V(FUN_DC) + 6.05141e-05*V(V_SUPPLY) + 6.05142e-05*V(MOST_POS) + 0.000858439*V(EN_LDO) + -0.000414209*meta_corner + -8.05626e-07*meta_temp + 6.05142e-05*meta_vsup_max + 4.25031e-05*V(VPWR)*V(VPWR) + 4.09895e-05*V(VPWR)*V(VREF) + -1.64958e-05*V(VPWR)*V(FUN_DC) + -1.64958e-05*V(VPWR)*V(V_SUPPLY) + -1.64958e-05*V(VPWR)*V(MOST_POS) + -1.32705e-05*V(VPWR)*V(EN_LDO) + 8.49561e-05*V(VPWR)*meta_corner + -1.59117e-07*V(VPWR)*meta_temp + -1.64958e-05*V(VPWR)*meta_vsup_max + -0.00122383*V(VREF)*V(VREF) + 4.236e-05*V(VREF)*V(FUN_DC) + 4.236e-05*V(VREF)*V(V_SUPPLY) + 4.236e-05*V(VREF)*V(MOST_POS) + 0.000600907*V(VREF)*V(EN_LDO) + -0.000289946*V(VREF)*meta_corner + -5.63969e-07*V(VREF)*meta_temp + 4.236e-05*V(VREF)*meta_vsup_max + 1.26238e-06*V(FUN_DC)*V(FUN_DC) + 1.26238e-06*V(FUN_DC)*V(V_SUPPLY) + 1.26238e-06*V(FUN_DC)*V(MOST_POS) + -3.48139e-06*V(FUN_DC)*V(EN_LDO) + -1.45021e-05*V(FUN_DC)*meta_corner + 4.47482e-08*V(FUN_DC)*meta_temp + 1.26238e-06*V(FUN_DC)*meta_vsup_max + 1.26238e-06*V(V_SUPPLY)*V(V_SUPPLY) + 1.26238e-06*V(V_SUPPLY)*V(MOST_POS) + -3.48139e-06*V(V_SUPPLY)*V(EN_LDO) + -1.45021e-05*V(V_SUPPLY)*meta_corner + 4.47255e-08*V(V_SUPPLY)*meta_temp + 1.26238e-06*V(V_SUPPLY)*meta_vsup_max + 1.26238e-06*V(MOST_POS)*V(MOST_POS) + -3.48139e-06*V(MOST_POS)*V(EN_LDO) + -1.45021e-05*V(MOST_POS)*meta_corner + 4.47575e-08*V(MOST_POS)*meta_temp + 1.26238e-06*V(MOST_POS)*meta_vsup_max + -0.000126029*V(EN_LDO)*V(EN_LDO) + 5.93269e-05*V(EN_LDO)*meta_corner + 2.04524e-07*V(EN_LDO)*meta_temp + -3.48139e-06*V(EN_LDO)*meta_vsup_max + -0.00107211*meta_corner*meta_corner + -5.57762e-08*meta_corner*meta_temp + -1.45021e-05*meta_corner*meta_vsup_max + -1.78311e-09*meta_temp*meta_temp + 4.47544e-08*meta_temp*meta_vsup_max + 1.26238e-06*meta_vsup_max*meta_vsup_max + -0.0179463*ddt(V(VREF)) + -0.286414*ddt(V(FUN_DC)) + -0.286414*ddt(V(V_SUPPLY)) + -0.286414*ddt(V(MOST_POS)) + 2.62117e-10*ddt(V(EN_LDO)) + 0.00402472*idt(V(VPWR)) + 0.0693813*idt(V(VREF)) + -0.00784116*idt(V(FUN_DC)) + -0.00118882*idt(V(V_SUPPLY)) + -0.00118882*idt(V(MOST_POS)) + -0.00421233*idt(V(EN_LDO)) + -0.00249762;  // MOST_POS_I
                V(VDD_1V2) <+ -0.82436*V(VPWR) + 13.2257*V(VREF) + -0.86966*V(FUN_DC) + -0.86966*V(V_SUPPLY) + -0.869659*V(MOST_POS) + -5.41551*V(EN_LDO) + 1.03168*meta_corner + 0.00243417*meta_temp + -0.869659*meta_vsup_max + -0.478877*V(VPWR)*V(VPWR) + -0.577052*V(VPWR)*V(VREF) + 0.166518*V(VPWR)*V(FUN_DC) + 0.166518*V(VPWR)*V(V_SUPPLY) + 0.166518*V(VPWR)*V(MOST_POS) + 0.290365*V(VPWR)*V(EN_LDO) + 0.722744*V(VPWR)*meta_corner + 0.00177475*V(VPWR)*meta_temp + 0.166518*V(VPWR)*meta_vsup_max + 9.25797*V(VREF)*V(VREF) + -0.608762*V(VREF)*V(FUN_DC) + -0.608762*V(VREF)*V(V_SUPPLY) + -0.608762*V(VREF)*V(MOST_POS) + -3.79086*V(VREF)*V(EN_LDO) + 0.722178*V(VREF)*meta_corner + 0.00170389*V(VREF)*meta_temp + -0.608762*V(VREF)*meta_vsup_max + 0.00897143*V(FUN_DC)*V(FUN_DC) + 0.00897143*V(FUN_DC)*V(V_SUPPLY) + 0.00897143*V(FUN_DC)*V(MOST_POS) + 0.063869*V(FUN_DC)*V(EN_LDO) + -0.135457*V(FUN_DC)*meta_corner + -0.000614704*V(FUN_DC)*meta_temp + 0.00897143*V(FUN_DC)*meta_vsup_max + 0.00897143*V(V_SUPPLY)*V(V_SUPPLY) + 0.00897143*V(V_SUPPLY)*V(MOST_POS) + 0.063869*V(V_SUPPLY)*V(EN_LDO) + -0.135457*V(V_SUPPLY)*meta_corner + -0.000614726*V(V_SUPPLY)*meta_temp + 0.00897143*V(V_SUPPLY)*meta_vsup_max + 0.00897143*V(MOST_POS)*V(MOST_POS) + 0.063869*V(MOST_POS)*V(EN_LDO) + -0.135457*V(MOST_POS)*meta_corner + -0.000614698*V(MOST_POS)*meta_temp + 0.00897143*V(MOST_POS)*meta_vsup_max + 0.716092*V(EN_LDO)*V(EN_LDO) + -0.188238*V(EN_LDO)*meta_corner + 0.000833921*V(EN_LDO)*meta_temp + 0.063869*V(EN_LDO)*meta_vsup_max + 1.41339*meta_corner*meta_corner + -0.00349892*meta_corner*meta_temp + -0.135457*meta_corner*meta_vsup_max + -2.76803e-05*meta_temp*meta_temp + -0.000614699*meta_temp*meta_vsup_max + 0.00897143*meta_vsup_max*meta_vsup_max + 8.58694e-08*ddt(V(VPWR)) + -15.0573*ddt(V(VREF)) + -240.323*ddt(V(FUN_DC)) + -240.323*ddt(V(V_SUPPLY)) + -240.323*ddt(V(MOST_POS)) + -7.05519e-07*ddt(V(EN_LDO)) + 174.066*idt(V(VPWR)) + -803.51*idt(V(VREF)) + 71.2792*idt(V(FUN_DC)) + -96.0348*idt(V(V_SUPPLY)) + -96.0348*idt(V(MOST_POS)) + 87.2463*idt(V(EN_LDO)) + 18.8938;
                I(VPWR, GND) <+ -0.0276456*V(VPWR) + 0.730112*V(VREF) + -0.0274138*V(FUN_DC) + -0.0274137*V(V_SUPPLY) + -0.0274137*V(MOST_POS) + -0.455457*V(EN_LDO) + -0.0661628*meta_corner + 9.94728e-05*meta_temp + -0.0274137*meta_vsup_max + 0.010267*V(VPWR)*V(VPWR) + -0.0193519*V(VPWR)*V(VREF) + -0.00281615*V(VPWR)*V(FUN_DC) + -0.00281615*V(VPWR)*V(V_SUPPLY) + -0.00281615*V(VPWR)*V(MOST_POS) + 0.00213246*V(VPWR)*V(EN_LDO) + -0.0113524*V(VPWR)*meta_corner + 7.59798e-05*V(VPWR)*meta_temp + -0.00281615*V(VPWR)*meta_vsup_max + 0.511078*V(VREF)*V(VREF) + -0.0191896*V(VREF)*V(FUN_DC) + -0.0191896*V(VREF)*V(V_SUPPLY) + -0.0191896*V(VREF)*V(MOST_POS) + -0.31882*V(VREF)*V(EN_LDO) + -0.0463139*V(VREF)*meta_corner + 6.96305e-05*V(VREF)*meta_temp + -0.0191896*V(VREF)*meta_vsup_max + 0.00150819*V(FUN_DC)*V(FUN_DC) + 0.00150819*V(FUN_DC)*V(V_SUPPLY) + 0.00150819*V(FUN_DC)*V(MOST_POS) + 0.00329174*V(FUN_DC)*V(EN_LDO) + 0.00397182*V(FUN_DC)*meta_corner + -1.75079e-05*V(FUN_DC)*meta_temp + 0.00150819*V(FUN_DC)*meta_vsup_max + 0.00150819*V(V_SUPPLY)*V(V_SUPPLY) + 0.00150819*V(V_SUPPLY)*V(MOST_POS) + 0.00329174*V(V_SUPPLY)*V(EN_LDO) + 0.00397182*V(V_SUPPLY)*meta_corner + -1.75082e-05*V(V_SUPPLY)*meta_temp + 0.00150819*V(V_SUPPLY)*meta_vsup_max + 0.00150819*V(MOST_POS)*V(MOST_POS) + 0.00329174*V(MOST_POS)*V(EN_LDO) + 0.00397182*V(MOST_POS)*meta_corner + -1.75077e-05*V(MOST_POS)*meta_temp + 0.00150819*V(MOST_POS)*meta_vsup_max + 0.0786936*V(EN_LDO)*V(EN_LDO) + -0.0784101*V(EN_LDO)*meta_corner + 3.40713e-05*V(EN_LDO)*meta_temp + 0.00329174*V(EN_LDO)*meta_vsup_max + -1.18671*meta_corner*meta_corner + -0.000305899*meta_corner*meta_temp + 0.00397182*meta_corner*meta_vsup_max + -3.24362e-06*meta_temp*meta_temp + -1.75078e-05*meta_temp*meta_vsup_max + 0.00150819*meta_vsup_max*meta_vsup_max + 7.30347e-09*ddt(V(VPWR)) + -0.264329*ddt(V(VREF)) + -4.21857*ddt(V(FUN_DC)) + -4.21857*ddt(V(V_SUPPLY)) + -4.21857*ddt(V(MOST_POS)) + -6.28638e-08*ddt(V(EN_LDO)) + 2.40109*idt(V(VPWR)) + 0.0454751*idt(V(VREF)) + -1.14352*idt(V(FUN_DC)) + -0.633097*idt(V(V_SUPPLY)) + -0.633097*idt(V(MOST_POS)) + 0.0378287*idt(V(EN_LDO)) + 1.04302;  // VPWR_I
                I(V_SUPPLY, GND) <+ 2.93779e-05*V(VPWR) + -0.000216853*V(VREF) + 3.56153e-05*V(FUN_DC) + 3.56153e-05*V(V_SUPPLY) + 3.56153e-05*V(MOST_POS) + -1.30059e-05*V(EN_LDO) + 1.39275e-05*meta_corner + -3.05894e-07*meta_temp + 3.56153e-05*meta_vsup_max + 2.13095e-05*V(VPWR)*V(VPWR) + 2.05645e-05*V(VPWR)*V(VREF) + -2.02459e-06*V(VPWR)*V(FUN_DC) + -2.02459e-06*V(VPWR)*V(V_SUPPLY) + -2.02459e-06*V(VPWR)*V(MOST_POS) + -3.36181e-05*V(VPWR)*V(EN_LDO) + 1.64471e-05*V(VPWR)*meta_corner + -1.92688e-08*V(VPWR)*meta_temp + -2.02459e-06*V(VPWR)*meta_vsup_max + -0.000151797*V(VREF)*V(VREF) + 2.49307e-05*V(VREF)*V(FUN_DC) + 2.49307e-05*V(VREF)*V(V_SUPPLY) + 2.49307e-05*V(VREF)*V(MOST_POS) + -9.10412e-06*V(VREF)*V(EN_LDO) + 9.74927e-06*V(VREF)*meta_corner + -2.14125e-07*V(VREF)*meta_temp + 2.49307e-05*V(VREF)*meta_vsup_max + -1.66821e-06*V(FUN_DC)*V(FUN_DC) + -1.66821e-06*V(FUN_DC)*V(V_SUPPLY) + -1.66821e-06*V(FUN_DC)*V(MOST_POS) + -2.43129e-06*V(FUN_DC)*V(EN_LDO) + 2.63229e-06*V(FUN_DC)*meta_corner + 1.52126e-10*V(FUN_DC)*meta_temp + -1.66821e-06*V(FUN_DC)*meta_vsup_max + -1.66821e-06*V(V_SUPPLY)*V(V_SUPPLY) + -1.66821e-06*V(V_SUPPLY)*V(MOST_POS) + -2.43129e-06*V(V_SUPPLY)*V(EN_LDO) + 2.63229e-06*V(V_SUPPLY)*meta_corner + 1.52948e-10*V(V_SUPPLY)*meta_temp + -1.66821e-06*V(V_SUPPLY)*meta_vsup_max + -1.66821e-06*V(MOST_POS)*V(MOST_POS) + -2.43129e-06*V(MOST_POS)*V(EN_LDO) + 2.63229e-06*V(MOST_POS)*meta_corner + 1.51802e-10*V(MOST_POS)*meta_temp + -1.66821e-06*V(MOST_POS)*meta_vsup_max + 2.27217e-05*V(EN_LDO)*V(EN_LDO) + -2.35148e-05*V(EN_LDO)*meta_corner + 8.87747e-08*V(EN_LDO)*meta_temp + -2.43129e-06*V(EN_LDO)*meta_vsup_max + 4.88272e-05*meta_corner*meta_corner + -4.54103e-08*meta_corner*meta_temp + 2.63229e-06*meta_corner*meta_vsup_max + 8.60675e-10*meta_temp*meta_temp + 1.51899e-10*meta_temp*meta_vsup_max + -1.66821e-06*meta_vsup_max*meta_vsup_max + 0.000640207*ddt(V(VREF)) + 0.0102176*ddt(V(FUN_DC)) + 0.0102176*ddt(V(V_SUPPLY)) + 0.0102176*ddt(V(MOST_POS)) + -0.000541556*idt(V(VPWR)) + 0.00162476*idt(V(VREF)) + -0.00653382*idt(V(FUN_DC)) + 0.00366574*idt(V(V_SUPPLY)) + 0.00366574*idt(V(MOST_POS)) + -0.000966912*idt(V(EN_LDO)) + -0.00030979;  // V_SUPPLY_I
            end
            DISABLED_2: begin
                I(FUN_DC, GND) <+ 0.000550591*V(VPWR) + -0.00131689*V(VREF) + 0.000550591*V(FUN_DC) + 0.000550591*V(V_SUPPLY) + 0.000550591*V(MOST_POS) + 0.000504678*V(EN_LDO) + -0.00138984*meta_corner + 7.06302e-06*meta_temp + 0.000550591*meta_vsup_max + -2.70203e-05*V(VPWR)*V(VPWR) + 0.000385414*V(VPWR)*V(VREF) + -2.70203e-05*V(VPWR)*V(FUN_DC) + -2.70203e-05*V(VPWR)*V(V_SUPPLY) + -2.70203e-05*V(VPWR)*V(MOST_POS) + -1.5447e-05*V(VPWR)*V(EN_LDO) + 6.34285e-05*V(VPWR)*meta_corner + -4.74588e-07*V(VPWR)*meta_temp + -2.70203e-05*V(VPWR)*meta_vsup_max + -0.00092182*V(VREF)*V(VREF) + 0.000385414*V(VREF)*V(FUN_DC) + 0.000385414*V(VREF)*V(V_SUPPLY) + 0.000385414*V(VREF)*V(MOST_POS) + 0.000353274*V(VREF)*V(EN_LDO) + -0.000972886*V(VREF)*meta_corner + 4.94412e-06*V(VREF)*meta_temp + 0.000385414*V(VREF)*meta_vsup_max + -2.70203e-05*V(FUN_DC)*V(FUN_DC) + -2.70203e-05*V(FUN_DC)*V(V_SUPPLY) + -2.70203e-05*V(FUN_DC)*V(MOST_POS) + -1.5447e-05*V(FUN_DC)*V(EN_LDO) + 6.34285e-05*V(FUN_DC)*meta_corner + -4.74603e-07*V(FUN_DC)*meta_temp + -2.70203e-05*V(FUN_DC)*meta_vsup_max + -2.70203e-05*V(V_SUPPLY)*V(V_SUPPLY) + -2.70203e-05*V(V_SUPPLY)*V(MOST_POS) + -1.5447e-05*V(V_SUPPLY)*V(EN_LDO) + 6.34285e-05*V(V_SUPPLY)*meta_corner + -4.74603e-07*V(V_SUPPLY)*meta_temp + -2.70203e-05*V(V_SUPPLY)*meta_vsup_max + -2.70203e-05*V(MOST_POS)*V(MOST_POS) + -1.5447e-05*V(MOST_POS)*V(EN_LDO) + 6.34285e-05*V(MOST_POS)*meta_corner + -4.74595e-07*V(MOST_POS)*meta_temp + -2.70203e-05*V(MOST_POS)*meta_vsup_max + -0.000121625*V(EN_LDO)*V(EN_LDO) + -0.000428898*V(EN_LDO)*meta_corner + 7.65219e-07*V(EN_LDO)*meta_temp + -1.5447e-05*V(EN_LDO)*meta_vsup_max + -0.00289324*meta_corner*meta_corner + -4.18562e-06*meta_corner*meta_temp + 6.34285e-05*meta_corner*meta_vsup_max + 8.55168e-09*meta_temp*meta_temp + -4.74605e-07*meta_temp*meta_vsup_max + -2.70203e-05*meta_vsup_max*meta_vsup_max + -0.297771*ddt(V(VPWR)) + -0.0200355*ddt(V(VREF)) + -0.297771*ddt(V(FUN_DC)) + -0.297771*ddt(V(V_SUPPLY)) + -0.297771*ddt(V(MOST_POS)) + 0.000999932*idt(V(VPWR)) + -0.382431*idt(V(VREF)) + 0.000999932*idt(V(FUN_DC)) + 0.000999932*idt(V(V_SUPPLY)) + 0.000999932*idt(V(MOST_POS)) + 0.000844563*idt(V(EN_LDO)) + -0.00188126;  // FUN_DC_I
                I(MOST_POS, GND) <+ 0.00443098*V(VPWR) + -0.0273436*V(VREF) + 0.00443098*V(FUN_DC) + 0.00443098*V(V_SUPPLY) + 0.00443098*V(MOST_POS) + -0.000318101*V(EN_LDO) + -0.00896734*meta_corner + 2.56481e-05*meta_temp + 0.00443098*meta_vsup_max + -3.95733e-05*V(VPWR)*V(VPWR) + 0.00310169*V(VPWR)*V(VREF) + -3.95733e-05*V(VPWR)*V(FUN_DC) + -3.95733e-05*V(VPWR)*V(V_SUPPLY) + -3.95733e-05*V(VPWR)*V(MOST_POS) + 6.69251e-05*V(VPWR)*V(EN_LDO) + 0.000154367*V(VPWR)*meta_corner + -1.21593e-06*V(VPWR)*meta_temp + -3.95733e-05*V(VPWR)*meta_vsup_max + -0.0191406*V(VREF)*V(VREF) + 0.00310169*V(VREF)*V(FUN_DC) + 0.00310169*V(VREF)*V(V_SUPPLY) + 0.00310169*V(VREF)*V(MOST_POS) + -0.000222671*V(VREF)*V(EN_LDO) + -0.00627714*V(VREF)*meta_corner + 1.79537e-05*V(VREF)*meta_temp + 0.00310169*V(VREF)*meta_vsup_max + -3.95733e-05*V(FUN_DC)*V(FUN_DC) + -3.95733e-05*V(FUN_DC)*V(V_SUPPLY) + -3.95733e-05*V(FUN_DC)*V(MOST_POS) + 6.69251e-05*V(FUN_DC)*V(EN_LDO) + 0.000154367*V(FUN_DC)*meta_corner + -1.21567e-06*V(FUN_DC)*meta_temp + -3.95733e-05*V(FUN_DC)*meta_vsup_max + -3.95733e-05*V(V_SUPPLY)*V(V_SUPPLY) + -3.95733e-05*V(V_SUPPLY)*V(MOST_POS) + 6.69251e-05*V(V_SUPPLY)*V(EN_LDO) + 0.000154367*V(V_SUPPLY)*meta_corner + -1.21566e-06*V(V_SUPPLY)*meta_temp + -3.95733e-05*V(V_SUPPLY)*meta_vsup_max + -3.95733e-05*V(MOST_POS)*V(MOST_POS) + 6.69251e-05*V(MOST_POS)*V(EN_LDO) + 0.000154367*V(MOST_POS)*meta_corner + -1.21582e-06*V(MOST_POS)*meta_temp + -3.95733e-05*V(MOST_POS)*meta_vsup_max + 0.00179172*V(EN_LDO)*V(EN_LDO) + 0.00142985*V(EN_LDO)*meta_corner + -8.65156e-06*V(EN_LDO)*meta_temp + 6.69251e-05*V(EN_LDO)*meta_vsup_max + -0.0305233*meta_corner*meta_corner + -2.12209e-06*meta_corner*meta_temp + 0.000154367*meta_corner*meta_vsup_max + -2.77776e-08*meta_temp*meta_temp + -1.21564e-06*meta_temp*meta_vsup_max + -3.95733e-05*meta_vsup_max*meta_vsup_max + 5.12566*ddt(V(VPWR)) + 0.343794*ddt(V(VREF)) + 5.12566*ddt(V(FUN_DC)) + 5.12566*ddt(V(V_SUPPLY)) + 5.12566*ddt(V(MOST_POS)) + -0.235104*idt(V(VPWR)) + 2.72359*idt(V(VREF)) + -0.235104*idt(V(FUN_DC)) + -0.235104*idt(V(V_SUPPLY)) + -0.235104*idt(V(MOST_POS)) + -0.0150204*idt(V(EN_LDO)) + -0.0390624;  // MOST_POS_I
                V(VDD_1V2) <+ -0.0897685*V(VPWR) + 3.69347*V(VREF) + -0.0897685*V(FUN_DC) + -0.0897685*V(V_SUPPLY) + -0.0897685*V(MOST_POS) + 0.60692*V(EN_LDO) + 2.66445*meta_corner + 0.00337287*meta_temp + -0.0897685*meta_vsup_max + -0.00330266*V(VPWR)*V(VPWR) + -0.0628379*V(VPWR)*V(VREF) + -0.00330266*V(VPWR)*V(FUN_DC) + -0.00330266*V(VPWR)*V(V_SUPPLY) + -0.00330266*V(VPWR)*V(MOST_POS) + -0.00528636*V(VPWR)*V(EN_LDO) + 0.0549305*V(VPWR)*meta_corner + -0.000100743*V(VPWR)*meta_temp + -0.00330266*V(VPWR)*meta_vsup_max + 2.58543*V(VREF)*V(VREF) + -0.0628379*V(VREF)*V(FUN_DC) + -0.0628379*V(VREF)*V(V_SUPPLY) + -0.0628379*V(VREF)*V(MOST_POS) + 0.424844*V(VREF)*V(EN_LDO) + 1.86511*V(VREF)*meta_corner + 0.00236101*V(VREF)*meta_temp + -0.0628379*V(VREF)*meta_vsup_max + -0.00330266*V(FUN_DC)*V(FUN_DC) + -0.00330266*V(FUN_DC)*V(V_SUPPLY) + -0.00330266*V(FUN_DC)*V(MOST_POS) + -0.00528636*V(FUN_DC)*V(EN_LDO) + 0.0549305*V(FUN_DC)*meta_corner + -0.000100743*V(FUN_DC)*meta_temp + -0.00330266*V(FUN_DC)*meta_vsup_max + -0.00330266*V(V_SUPPLY)*V(V_SUPPLY) + -0.00330266*V(V_SUPPLY)*V(MOST_POS) + -0.00528636*V(V_SUPPLY)*V(EN_LDO) + 0.0549305*V(V_SUPPLY)*meta_corner + -0.000100743*V(V_SUPPLY)*meta_temp + -0.00330266*V(V_SUPPLY)*meta_vsup_max + -0.00330266*V(MOST_POS)*V(MOST_POS) + -0.00528636*V(MOST_POS)*V(EN_LDO) + 0.0549305*V(MOST_POS)*meta_corner + -0.000100744*V(MOST_POS)*meta_temp + -0.00330266*V(MOST_POS)*meta_vsup_max + -0.201553*V(EN_LDO)*V(EN_LDO) + 0.32659*V(EN_LDO)*meta_corner + 6.63099e-05*V(EN_LDO)*meta_temp + -0.00528636*V(EN_LDO)*meta_vsup_max + 12.0692*meta_corner*meta_corner + 0.00466366*meta_corner*meta_temp + 0.0549305*meta_corner*meta_vsup_max + -1.05877e-05*meta_temp*meta_temp + -0.000100745*meta_temp*meta_vsup_max + -0.00330266*meta_vsup_max*meta_vsup_max + 1.92592*ddt(V(VPWR)) + -0.0399796*ddt(V(VREF)) + 1.92592*ddt(V(FUN_DC)) + 1.92592*ddt(V(V_SUPPLY)) + 1.92592*ddt(V(MOST_POS)) + -9.49905e-10*ddt(V(EN_LDO)) + 10.1575*idt(V(VPWR)) + -593.988*idt(V(VREF)) + 10.1575*idt(V(FUN_DC)) + 10.1575*idt(V(V_SUPPLY)) + 10.1575*idt(V(MOST_POS)) + 1.90612*idt(V(EN_LDO)) + 5.27639;
                I(VPWR, GND) <+ 0.00686153*V(VPWR) + 0.157796*V(VREF) + 0.00686153*V(FUN_DC) + 0.00686153*V(V_SUPPLY) + 0.00686153*V(MOST_POS) + 0.0580214*V(EN_LDO) + -0.110345*meta_corner + 0.000110366*meta_temp + 0.00686153*meta_vsup_max + -0.00153923*V(VPWR)*V(VPWR) + 0.00480307*V(VPWR)*V(VREF) + -0.00153923*V(VPWR)*V(FUN_DC) + -0.00153923*V(VPWR)*V(V_SUPPLY) + -0.00153923*V(VPWR)*V(MOST_POS) + -0.00555235*V(VPWR)*V(EN_LDO) + 0.00300353*V(VPWR)*meta_corner + -6.26569e-06*V(VPWR)*meta_temp + -0.00153923*V(VPWR)*meta_vsup_max + 0.110457*V(VREF)*V(VREF) + 0.00480307*V(VREF)*V(FUN_DC) + 0.00480307*V(VREF)*V(V_SUPPLY) + 0.00480307*V(VREF)*V(MOST_POS) + 0.040615*V(VREF)*V(EN_LDO) + -0.0772416*V(VREF)*meta_corner + 7.72562e-05*V(VREF)*meta_temp + 0.00480307*V(VREF)*meta_vsup_max + -0.00153923*V(FUN_DC)*V(FUN_DC) + -0.00153923*V(FUN_DC)*V(V_SUPPLY) + -0.00153923*V(FUN_DC)*V(MOST_POS) + -0.00555235*V(FUN_DC)*V(EN_LDO) + 0.00300353*V(FUN_DC)*meta_corner + -6.26481e-06*V(FUN_DC)*meta_temp + -0.00153923*V(FUN_DC)*meta_vsup_max + -0.00153923*V(V_SUPPLY)*V(V_SUPPLY) + -0.00153923*V(V_SUPPLY)*V(MOST_POS) + -0.00555235*V(V_SUPPLY)*V(EN_LDO) + 0.00300353*V(V_SUPPLY)*meta_corner + -6.26478e-06*V(V_SUPPLY)*meta_temp + -0.00153923*V(V_SUPPLY)*meta_vsup_max + -0.00153923*V(MOST_POS)*V(MOST_POS) + -0.00555235*V(MOST_POS)*V(EN_LDO) + 0.00300353*V(MOST_POS)*meta_corner + -6.26542e-06*V(MOST_POS)*meta_temp + -0.00153923*V(MOST_POS)*meta_vsup_max + 0.0374836*V(EN_LDO)*V(EN_LDO) + -0.0346586*V(EN_LDO)*meta_corner + -0.000100315*V(EN_LDO)*meta_temp + -0.00555235*V(EN_LDO)*meta_vsup_max + -0.428829*meta_corner*meta_corner + -0.000172427*meta_corner*meta_temp + 0.00300353*meta_corner*meta_vsup_max + 3.82403e-07*meta_temp*meta_temp + -6.26485e-06*meta_temp*meta_vsup_max + -0.00153923*meta_vsup_max*meta_vsup_max + 17.748*ddt(V(VPWR)) + 1.17316*ddt(V(VREF)) + 17.748*ddt(V(FUN_DC)) + 17.748*ddt(V(V_SUPPLY)) + 17.748*ddt(V(MOST_POS)) + 1.67323*idt(V(VPWR)) + -51.0464*idt(V(VREF)) + 1.67323*idt(V(FUN_DC)) + 1.67323*idt(V(V_SUPPLY)) + 1.67323*idt(V(MOST_POS)) + 0.122066*idt(V(EN_LDO)) + 0.225422;  // VPWR_I
                I(V_SUPPLY, GND) <+ 9.61929e-05*V(VPWR) + -0.00115013*V(VREF) + 9.61929e-05*V(FUN_DC) + 9.61929e-05*V(V_SUPPLY) + 9.61929e-05*V(MOST_POS) + -8.25243e-05*V(EN_LDO) + -0.000352033*meta_corner + 5.49743e-07*meta_temp + 9.61929e-05*meta_vsup_max + -4.00242e-07*V(VPWR)*V(VPWR) + 6.7335e-05*V(VPWR)*V(VREF) + -4.00242e-07*V(VPWR)*V(FUN_DC) + -4.00242e-07*V(VPWR)*V(V_SUPPLY) + -4.00242e-07*V(VPWR)*V(MOST_POS) + 1.24545e-05*V(VPWR)*V(EN_LDO) + 7.88522e-06*V(VPWR)*meta_corner + -3.32738e-08*V(VPWR)*meta_temp + -4.00242e-07*V(VPWR)*meta_vsup_max + -0.000805094*V(VREF)*V(VREF) + 6.7335e-05*V(VREF)*V(FUN_DC) + 6.7335e-05*V(VREF)*V(V_SUPPLY) + 6.7335e-05*V(VREF)*V(MOST_POS) + -5.7767e-05*V(VREF)*V(EN_LDO) + -0.000246423*V(VREF)*meta_corner + 3.84821e-07*V(VREF)*meta_temp + 6.7335e-05*V(VREF)*meta_vsup_max + -4.00242e-07*V(FUN_DC)*V(FUN_DC) + -4.00242e-07*V(FUN_DC)*V(V_SUPPLY) + -4.00242e-07*V(FUN_DC)*V(MOST_POS) + 1.24545e-05*V(FUN_DC)*V(EN_LDO) + 7.88522e-06*V(FUN_DC)*meta_corner + -3.32735e-08*V(FUN_DC)*meta_temp + -4.00242e-07*V(FUN_DC)*meta_vsup_max + -4.00242e-07*V(V_SUPPLY)*V(V_SUPPLY) + -4.00242e-07*V(V_SUPPLY)*V(MOST_POS) + 1.24545e-05*V(V_SUPPLY)*V(EN_LDO) + 7.88522e-06*V(V_SUPPLY)*meta_corner + -3.32735e-08*V(V_SUPPLY)*meta_temp + -4.00242e-07*V(V_SUPPLY)*meta_vsup_max + -4.00242e-07*V(MOST_POS)*V(MOST_POS) + 1.24545e-05*V(MOST_POS)*V(EN_LDO) + 7.88522e-06*V(MOST_POS)*meta_corner + -3.32734e-08*V(MOST_POS)*meta_temp + -4.00242e-07*V(MOST_POS)*meta_vsup_max + -2.15294e-05*V(EN_LDO)*V(EN_LDO) + 4.8346e-05*V(EN_LDO)*meta_corner + -2.86616e-07*V(EN_LDO)*meta_temp + 1.24545e-05*V(EN_LDO)*meta_vsup_max + -0.0013764*meta_corner*meta_corner + -2.67324e-07*meta_corner*meta_temp + 7.88522e-06*meta_corner*meta_vsup_max + 8.00657e-10*meta_temp*meta_temp + -3.32732e-08*meta_temp*meta_vsup_max + -4.00242e-07*meta_vsup_max*meta_vsup_max + 0.00413241*ddt(V(VPWR)) + 0.000315182*ddt(V(VREF)) + 0.00413241*ddt(V(FUN_DC)) + 0.00413241*ddt(V(V_SUPPLY)) + 0.00413241*ddt(V(MOST_POS)) + -0.00563909*idt(V(VPWR)) + 0.135424*idt(V(VREF)) + -0.00563909*idt(V(FUN_DC)) + -0.00563909*idt(V(V_SUPPLY)) + -0.00563909*idt(V(MOST_POS)) + -0.000493556*idt(V(EN_LDO)) + -0.00164305;  // V_SUPPLY_I
            end
            REGULATION_6: begin
                I(FUN_DC, GND) <+ 8.15317e-07*V(VPWR) + -2.70164e-07*V(VREF) + 8.15318e-07*V(FUN_DC) + 8.15317e-07*V(V_SUPPLY) + 8.15317e-07*V(MOST_POS) + -1.9298e-06*V(EN_LDO) + 3.20091e-06*meta_corner + -8.20342e-09*meta_temp + 8.15317e-07*meta_vsup_max + -7.5155e-07*V(VPWR)*V(VPWR) + 5.70722e-07*V(VPWR)*V(VREF) + -7.5155e-07*V(VPWR)*V(FUN_DC) + -7.5155e-07*V(VPWR)*V(V_SUPPLY) + -7.5155e-07*V(VPWR)*V(MOST_POS) + 4.07658e-06*V(VPWR)*V(EN_LDO) + -3.14243e-06*V(VPWR)*meta_corner + 7.4964e-09*V(VPWR)*meta_temp + -7.5155e-07*V(VPWR)*meta_vsup_max + -1.8912e-07*V(VREF)*V(VREF) + 5.70722e-07*V(VREF)*V(FUN_DC) + 5.70722e-07*V(VREF)*V(V_SUPPLY) + 5.70722e-07*V(VREF)*V(MOST_POS) + -1.35086e-06*V(VREF)*V(EN_LDO) + 2.24064e-06*V(VREF)*meta_corner + -5.7471e-09*V(VREF)*meta_temp + 5.70722e-07*V(VREF)*meta_vsup_max + -7.5155e-07*V(FUN_DC)*V(FUN_DC) + -7.5155e-07*V(FUN_DC)*V(V_SUPPLY) + -7.5155e-07*V(FUN_DC)*V(MOST_POS) + 4.07658e-06*V(FUN_DC)*V(EN_LDO) + -3.14243e-06*V(FUN_DC)*meta_corner + 7.49663e-09*V(FUN_DC)*meta_temp + -7.5155e-07*V(FUN_DC)*meta_vsup_max + -7.5155e-07*V(V_SUPPLY)*V(V_SUPPLY) + -7.5155e-07*V(V_SUPPLY)*V(MOST_POS) + 4.07658e-06*V(V_SUPPLY)*V(EN_LDO) + -3.14243e-06*V(V_SUPPLY)*meta_corner + 7.49736e-09*V(V_SUPPLY)*meta_temp + -7.5155e-07*V(V_SUPPLY)*meta_vsup_max + -7.5155e-07*V(MOST_POS)*V(MOST_POS) + 4.07658e-06*V(MOST_POS)*V(EN_LDO) + -3.14243e-06*V(MOST_POS)*meta_corner + 7.49658e-09*V(MOST_POS)*meta_temp + -7.5155e-07*V(MOST_POS)*meta_vsup_max + -9.64898e-06*V(EN_LDO)*V(EN_LDO) + 1.60046e-05*V(EN_LDO)*meta_corner + -4.10731e-08*V(EN_LDO)*meta_temp + 4.07658e-06*V(EN_LDO)*meta_vsup_max + 8.09144e-06*meta_corner*meta_corner + -6.838e-08*meta_corner*meta_temp + -3.14243e-06*meta_corner*meta_vsup_max + 2.71432e-10*meta_temp*meta_temp + 7.49704e-09*meta_temp*meta_vsup_max + -7.5155e-07*meta_vsup_max*meta_vsup_max + 0.000341424*ddt(V(VPWR)) + -0.00831609*ddt(V(VREF)) + 0.000341424*ddt(V(FUN_DC)) + 0.000341424*ddt(V(V_SUPPLY)) + 0.000341424*ddt(V(MOST_POS)) + -0.00195617*ddt(V(EN_LDO)) + 1.45224e-05*idt(V(VPWR)) + -8.40597e-06*idt(V(VREF)) + 1.45224e-05*idt(V(FUN_DC)) + 1.45224e-05*idt(V(V_SUPPLY)) + 1.45224e-05*idt(V(MOST_POS)) + -6.00435e-05*idt(V(EN_LDO)) + -3.85959e-07;  // FUN_DC_I
                I(MOST_POS, GND) <+ -2.13353e-06*V(VPWR) + 8.32795e-07*V(VREF) + -2.13338e-06*V(FUN_DC) + -2.13352e-06*V(V_SUPPLY) + -2.13352e-06*V(MOST_POS) + 5.94033e-06*V(EN_LDO) + -3.26348e-06*meta_corner + -5.44197e-08*meta_temp + -2.13352e-06*meta_vsup_max + 2.33291e-06*V(VPWR)*V(VPWR) + -1.49347e-06*V(VPWR)*V(VREF) + 2.33291e-06*V(VPWR)*V(FUN_DC) + 2.33291e-06*V(VPWR)*V(V_SUPPLY) + 2.33291e-06*V(VPWR)*V(MOST_POS) + -1.06676e-05*V(VPWR)*V(EN_LDO) + -2.04377e-05*V(VPWR)*meta_corner + 6.73338e-08*V(VPWR)*meta_temp + 2.33291e-06*V(VPWR)*meta_vsup_max + 5.82152e-07*V(VREF)*V(VREF) + -1.49347e-06*V(VREF)*V(FUN_DC) + -1.49347e-06*V(VREF)*V(V_SUPPLY) + -1.49347e-06*V(VREF)*V(MOST_POS) + 4.15822e-06*V(VREF)*V(EN_LDO) + -2.28444e-06*V(VREF)*meta_corner + -3.88189e-08*V(VREF)*meta_temp + -1.49347e-06*V(VREF)*meta_vsup_max + 2.33291e-06*V(FUN_DC)*V(FUN_DC) + 2.33291e-06*V(FUN_DC)*V(V_SUPPLY) + 2.33291e-06*V(FUN_DC)*V(MOST_POS) + -1.06676e-05*V(FUN_DC)*V(EN_LDO) + -2.04377e-05*V(FUN_DC)*meta_corner + 6.73686e-08*V(FUN_DC)*meta_temp + 2.33291e-06*V(FUN_DC)*meta_vsup_max + 2.33291e-06*V(V_SUPPLY)*V(V_SUPPLY) + 2.33291e-06*V(V_SUPPLY)*V(MOST_POS) + -1.06676e-05*V(V_SUPPLY)*V(EN_LDO) + -2.04377e-05*V(V_SUPPLY)*meta_corner + 6.74815e-08*V(V_SUPPLY)*meta_temp + 2.33291e-06*V(V_SUPPLY)*meta_vsup_max + 2.33291e-06*V(MOST_POS)*V(MOST_POS) + -1.06676e-05*V(MOST_POS)*V(EN_LDO) + -2.04377e-05*V(MOST_POS)*meta_corner + 6.73666e-08*V(MOST_POS)*meta_temp + 2.33291e-06*V(MOST_POS)*meta_vsup_max + 2.97016e-05*V(EN_LDO)*V(EN_LDO) + -1.63173e-05*V(EN_LDO)*meta_corner + -2.80692e-07*V(EN_LDO)*meta_temp + -1.06676e-05*V(EN_LDO)*meta_vsup_max + -0.0022182*meta_corner*meta_corner + 9.0891e-07*meta_corner*meta_temp + -2.04378e-05*meta_corner*meta_vsup_max + -3.83886e-09*meta_temp*meta_temp + 6.74385e-08*meta_temp*meta_vsup_max + 2.33291e-06*meta_vsup_max*meta_vsup_max + 0.330215*ddt(V(VPWR)) + -1.24684*ddt(V(VREF)) + 0.330215*ddt(V(FUN_DC)) + 0.330215*ddt(V(V_SUPPLY)) + 0.330215*ddt(V(MOST_POS)) + -0.378827*ddt(V(EN_LDO)) + 0.000305943*idt(V(VPWR)) + -1.43124e-05*idt(V(VREF)) + 0.000305943*idt(V(FUN_DC)) + 0.000305943*idt(V(V_SUPPLY)) + 0.000305943*idt(V(MOST_POS)) + -0.000102365*idt(V(EN_LDO)) + 1.18806e-06;  // MOST_POS_I
                V(VDD_1V2) <+ 0.0189897*V(VPWR) + -0.00672093*V(VREF) + 0.0189897*V(FUN_DC) + 0.0189897*V(V_SUPPLY) + 0.0189897*V(MOST_POS) + -0.0480056*V(EN_LDO) + 0.31476*meta_corner + 0.000354684*meta_temp + 0.0189897*meta_vsup_max + -0.0175818*V(VPWR)*V(VPWR) + 0.0132928*V(VPWR)*V(VREF) + -0.0175818*V(VPWR)*V(FUN_DC) + -0.0175818*V(VPWR)*V(V_SUPPLY) + -0.0175818*V(VPWR)*V(MOST_POS) + 0.0949487*V(VPWR)*V(EN_LDO) + 0.107993*V(VPWR)*meta_corner + -0.000301081*V(VPWR)*meta_temp + -0.0175818*V(VPWR)*meta_vsup_max + -0.00470455*V(VREF)*V(VREF) + 0.0132928*V(VREF)*V(FUN_DC) + 0.0132928*V(VREF)*V(V_SUPPLY) + 0.0132928*V(VREF)*V(MOST_POS) + -0.033604*V(VREF)*V(EN_LDO) + 0.220332*V(VREF)*meta_corner + 0.000248371*V(VREF)*meta_temp + 0.0132928*V(VREF)*meta_vsup_max + -0.0175818*V(FUN_DC)*V(FUN_DC) + -0.0175818*V(FUN_DC)*V(V_SUPPLY) + -0.0175818*V(FUN_DC)*V(MOST_POS) + 0.0949487*V(FUN_DC)*V(EN_LDO) + 0.107993*V(FUN_DC)*meta_corner + -0.000301086*V(FUN_DC)*meta_temp + -0.0175818*V(FUN_DC)*meta_vsup_max + -0.0175818*V(V_SUPPLY)*V(V_SUPPLY) + -0.0175818*V(V_SUPPLY)*V(MOST_POS) + 0.0949487*V(V_SUPPLY)*V(EN_LDO) + 0.107993*V(V_SUPPLY)*meta_corner + -0.0003011*V(V_SUPPLY)*meta_temp + -0.0175818*V(V_SUPPLY)*meta_vsup_max + -0.0175818*V(MOST_POS)*V(MOST_POS) + 0.0949487*V(MOST_POS)*V(EN_LDO) + 0.107993*V(MOST_POS)*meta_corner + -0.000301084*V(MOST_POS)*meta_temp + -0.0175818*V(MOST_POS)*meta_vsup_max + -0.240028*V(EN_LDO)*V(EN_LDO) + 1.5738*V(EN_LDO)*meta_corner + 0.00177451*V(EN_LDO)*meta_temp + 0.0949487*V(EN_LDO)*meta_vsup_max + 22.5748*meta_corner*meta_corner + 0.00207158*meta_corner*meta_temp + 0.107993*meta_corner*meta_vsup_max + -6.00613e-06*meta_temp*meta_temp + -0.000301093*meta_temp*meta_vsup_max + -0.0175818*meta_vsup_max*meta_vsup_max + -10.0978*ddt(V(VPWR)) + 160.65*ddt(V(VREF)) + -10.0978*ddt(V(FUN_DC)) + -10.0978*ddt(V(V_SUPPLY)) + -10.0978*ddt(V(MOST_POS)) + 27.7218*ddt(V(EN_LDO)) + 12.7545*idt(V(VPWR)) + -7.66853*idt(V(VREF)) + 12.7545*idt(V(FUN_DC)) + 12.7545*idt(V(V_SUPPLY)) + 12.7545*idt(V(MOST_POS)) + -54.7752*idt(V(EN_LDO)) + -0.00960113;
                I(VPWR, GND) <+ -0.000119791*V(VPWR) + 6.35883e-05*V(VREF) + -0.000119792*V(FUN_DC) + -0.000119791*V(V_SUPPLY) + -0.000119791*V(MOST_POS) + 0.000454271*V(EN_LDO) + -0.000654637*meta_corner + -3.80514e-06*meta_temp + -0.000119791*meta_vsup_max + 0.000110004*V(VPWR)*V(VPWR) + -8.38537e-05*V(VPWR)*V(VREF) + 0.000110004*V(VPWR)*V(FUN_DC) + 0.000110004*V(VPWR)*V(V_SUPPLY) + 0.000110004*V(VPWR)*V(MOST_POS) + -0.000598955*V(VPWR)*V(EN_LDO) + -0.00131254*V(VPWR)*meta_corner + 6.00941e-06*V(VPWR)*meta_temp + 0.000110004*V(VPWR)*meta_vsup_max + 4.45185e-05*V(VREF)*V(VREF) + -8.38537e-05*V(VREF)*V(FUN_DC) + -8.38537e-05*V(VREF)*V(V_SUPPLY) + -8.38537e-05*V(VREF)*V(MOST_POS) + 0.000317989*V(VREF)*V(EN_LDO) + -0.000458246*V(VREF)*meta_corner + -2.65578e-06*V(VREF)*meta_temp + -8.38537e-05*V(VREF)*meta_vsup_max + 0.000110004*V(FUN_DC)*V(FUN_DC) + 0.000110004*V(FUN_DC)*V(V_SUPPLY) + 0.000110004*V(FUN_DC)*V(MOST_POS) + -0.000598955*V(FUN_DC)*V(EN_LDO) + -0.00131254*V(FUN_DC)*meta_corner + 6.00907e-06*V(FUN_DC)*meta_temp + 0.000110004*V(FUN_DC)*meta_vsup_max + 0.000110004*V(V_SUPPLY)*V(V_SUPPLY) + 0.000110004*V(V_SUPPLY)*V(MOST_POS) + -0.000598955*V(V_SUPPLY)*V(EN_LDO) + -0.00131254*V(V_SUPPLY)*meta_corner + 6.00823e-06*V(V_SUPPLY)*meta_temp + 0.000110004*V(V_SUPPLY)*meta_vsup_max + 0.000110004*V(MOST_POS)*V(MOST_POS) + -0.000598955*V(MOST_POS)*V(EN_LDO) + -0.00131254*V(MOST_POS)*meta_corner + 6.00951e-06*V(MOST_POS)*meta_temp + 0.000110004*V(MOST_POS)*meta_vsup_max + 0.00227135*V(EN_LDO)*V(EN_LDO) + -0.00327319*V(EN_LDO)*meta_corner + -1.89357e-05*V(EN_LDO)*meta_temp + -0.000598955*V(EN_LDO)*meta_vsup_max + -0.155393*meta_corner*meta_corner + -0.000181324*meta_corner*meta_temp + -0.00131254*meta_corner*meta_vsup_max + 1.35338e-07*meta_temp*meta_temp + 6.00865e-06*meta_temp*meta_vsup_max + 0.000110004*meta_vsup_max*meta_vsup_max + 2.05013*ddt(V(VPWR)) + 11.8225*ddt(V(VREF)) + 2.05013*ddt(V(FUN_DC)) + 2.05013*ddt(V(V_SUPPLY)) + 2.05013*ddt(V(MOST_POS)) + -10.5084*ddt(V(EN_LDO)) + -0.0168593*idt(V(VPWR)) + 0.0101739*idt(V(VREF)) + -0.0168593*idt(V(FUN_DC)) + -0.0168593*idt(V(V_SUPPLY)) + -0.0168593*idt(V(MOST_POS)) + 0.0726716*idt(V(EN_LDO)) + 9.08541e-05;  // VPWR_I
                I(V_SUPPLY, GND) <+ -1.21482e-09*V(VPWR) + 2.44414e-10*V(VREF) + -1.21484e-09*V(FUN_DC) + -1.21482e-09*V(V_SUPPLY) + -1.21482e-09*V(MOST_POS) + 1.74744e-09*V(EN_LDO) + -3.35388e-08*meta_corner + -4.09976e-10*meta_temp + -1.21482e-09*meta_vsup_max + 1.66207e-09*V(VPWR)*V(VPWR) + -8.50372e-10*V(VPWR)*V(VREF) + 1.66207e-09*V(VPWR)*V(FUN_DC) + 1.66207e-09*V(VPWR)*V(V_SUPPLY) + 1.66207e-09*V(VPWR)*V(MOST_POS) + -6.07408e-09*V(VPWR)*V(EN_LDO) + 2.18869e-08*V(VPWR)*meta_corner + 4.3955e-10*V(VPWR)*meta_temp + 1.66207e-09*V(VPWR)*meta_vsup_max + 1.71249e-10*V(VREF)*V(VREF) + -8.50372e-10*V(VREF)*V(FUN_DC) + -8.50372e-10*V(VREF)*V(V_SUPPLY) + -8.50372e-10*V(VREF)*V(MOST_POS) + 1.22321e-09*V(VREF)*V(EN_LDO) + -2.34772e-08*V(VREF)*meta_corner + -2.86815e-10*V(VREF)*meta_temp + -8.50372e-10*V(VREF)*meta_vsup_max + 1.66207e-09*V(FUN_DC)*V(FUN_DC) + 1.66207e-09*V(FUN_DC)*V(V_SUPPLY) + 1.66207e-09*V(FUN_DC)*V(MOST_POS) + -6.07408e-09*V(FUN_DC)*V(EN_LDO) + 2.18869e-08*V(FUN_DC)*meta_corner + 4.39542e-10*V(FUN_DC)*meta_temp + 1.66207e-09*V(FUN_DC)*meta_vsup_max + 1.66207e-09*V(V_SUPPLY)*V(V_SUPPLY) + 1.66207e-09*V(V_SUPPLY)*V(MOST_POS) + -6.07408e-09*V(V_SUPPLY)*V(EN_LDO) + 2.18869e-08*V(V_SUPPLY)*meta_corner + 4.39521e-10*V(V_SUPPLY)*meta_temp + 1.66207e-09*V(V_SUPPLY)*meta_vsup_max + 1.66207e-09*V(MOST_POS)*V(MOST_POS) + -6.07408e-09*V(MOST_POS)*V(EN_LDO) + 2.18869e-08*V(MOST_POS)*meta_corner + 4.39548e-10*V(MOST_POS)*meta_temp + 1.66207e-09*V(MOST_POS)*meta_vsup_max + 8.7372e-09*V(EN_LDO)*V(EN_LDO) + -1.67694e-07*V(EN_LDO)*meta_corner + -2.04791e-09*V(EN_LDO)*meta_temp + -6.07408e-09*V(EN_LDO)*meta_vsup_max + -1.49258e-06*meta_corner*meta_corner + 2.18869e-08*meta_corner*meta_vsup_max + 4.39531e-10*meta_temp*meta_vsup_max + 1.66207e-09*meta_vsup_max*meta_vsup_max + 1.35694e-05*ddt(V(VPWR)) + 0.00027203*ddt(V(VREF)) + 1.35694e-05*ddt(V(FUN_DC)) + 1.35694e-05*ddt(V(V_SUPPLY)) + 1.35694e-05*ddt(V(MOST_POS)) + -0.000100716*ddt(V(EN_LDO)) + -6.48828e-07*idt(V(VPWR)) + 3.66129e-07*idt(V(VREF)) + -6.48828e-07*idt(V(FUN_DC)) + -6.48828e-07*idt(V(V_SUPPLY)) + -6.48828e-07*idt(V(MOST_POS)) + 2.61523e-06*idt(V(EN_LDO)) + 3.49488e-10;  // V_SUPPLY_I
            end
            REGULATION_7: begin
                I(FUN_DC, GND) <+ 7.52583e-07*V(VPWR) + -2.52921e-07*V(VREF) + 7.52583e-07*V(FUN_DC) + 7.52583e-07*V(V_SUPPLY) + 7.52583e-07*V(MOST_POS) + -1.80658e-06*V(EN_LDO) + 3.19045e-06*meta_corner + -9.53343e-09*meta_temp + 7.52583e-07*meta_vsup_max + -6.85505e-07*V(VPWR)*V(VPWR) + 5.26808e-07*V(VPWR)*V(VREF) + -6.85505e-07*V(VPWR)*V(FUN_DC) + -6.85505e-07*V(VPWR)*V(V_SUPPLY) + -6.85505e-07*V(VPWR)*V(MOST_POS) + 3.76291e-06*V(VPWR)*V(EN_LDO) + -3.13068e-06*V(VPWR)*meta_corner + 8.83474e-09*V(VPWR)*meta_temp + -6.85505e-07*V(VPWR)*meta_vsup_max + -1.77045e-07*V(VREF)*V(VREF) + 5.26808e-07*V(VREF)*V(FUN_DC) + 5.26808e-07*V(VREF)*V(V_SUPPLY) + 5.26808e-07*V(VREF)*V(MOST_POS) + -1.2646e-06*V(VREF)*V(EN_LDO) + 2.23332e-06*V(VREF)*meta_corner + -6.67338e-09*V(VREF)*meta_temp + 5.26808e-07*V(VREF)*meta_vsup_max + -6.85505e-07*V(FUN_DC)*V(FUN_DC) + -6.85505e-07*V(FUN_DC)*V(V_SUPPLY) + -6.85505e-07*V(FUN_DC)*V(MOST_POS) + 3.76291e-06*V(FUN_DC)*V(EN_LDO) + -3.13068e-06*V(FUN_DC)*meta_corner + 8.83473e-09*V(FUN_DC)*meta_temp + -6.85505e-07*V(FUN_DC)*meta_vsup_max + -6.85505e-07*V(V_SUPPLY)*V(V_SUPPLY) + -6.85505e-07*V(V_SUPPLY)*V(MOST_POS) + 3.76291e-06*V(V_SUPPLY)*V(EN_LDO) + -3.13068e-06*V(V_SUPPLY)*meta_corner + 8.83474e-09*V(V_SUPPLY)*meta_temp + -6.85505e-07*V(V_SUPPLY)*meta_vsup_max + -6.85505e-07*V(MOST_POS)*V(MOST_POS) + 3.76291e-06*V(MOST_POS)*V(EN_LDO) + -3.13068e-06*V(MOST_POS)*meta_corner + 8.83469e-09*V(MOST_POS)*meta_temp + -6.85505e-07*V(MOST_POS)*meta_vsup_max + -9.03289e-06*V(EN_LDO)*V(EN_LDO) + 1.59523e-05*V(EN_LDO)*meta_corner + -4.76672e-08*V(EN_LDO)*meta_temp + 3.76291e-06*V(EN_LDO)*meta_vsup_max + 7.23368e-06*meta_corner*meta_corner + -6.03268e-08*meta_corner*meta_temp + -3.13068e-06*meta_corner*meta_vsup_max + 2.87563e-10*meta_temp*meta_temp + 8.83472e-09*meta_temp*meta_vsup_max + -6.85505e-07*meta_vsup_max*meta_vsup_max + -0.000162534*ddt(V(VPWR)) + -8.56153e-05*ddt(V(VREF)) + -0.000162534*ddt(V(FUN_DC)) + -0.000162534*ddt(V(V_SUPPLY)) + -0.000162534*ddt(V(MOST_POS)) + 0.000679282*ddt(V(EN_LDO)) + -4.22458e-05*idt(V(VPWR)) + 2.42163e-05*idt(V(VREF)) + -4.22458e-05*idt(V(FUN_DC)) + -4.22458e-05*idt(V(V_SUPPLY)) + -4.22458e-05*idt(V(MOST_POS)) + 0.000172974*idt(V(EN_LDO)) + -3.61315e-07;  // FUN_DC_I
                I(MOST_POS, GND) <+ 2.90496e-06*V(VPWR) + -1.08029e-06*V(VREF) + 2.90539e-06*V(FUN_DC) + 2.90494e-06*V(V_SUPPLY) + 2.90495e-06*V(MOST_POS) + -7.71843e-06*V(EN_LDO) + -1.2653e-05*meta_corner + -1.74932e-08*meta_temp + 2.90494e-06*meta_vsup_max + -1.85119e-06*V(VPWR)*V(VPWR) + 2.03345e-06*V(VPWR)*V(VREF) + -1.8512e-06*V(VPWR)*V(FUN_DC) + -1.8512e-06*V(VPWR)*V(V_SUPPLY) + -1.8512e-06*V(VPWR)*V(MOST_POS) + 1.45247e-05*V(VPWR)*V(EN_LDO) + 4.03487e-06*V(VPWR)*meta_corner + 3.16375e-09*V(VPWR)*meta_temp + -1.8512e-06*V(VPWR)*meta_vsup_max + -7.56406e-07*V(VREF)*V(VREF) + 2.03345e-06*V(VREF)*V(FUN_DC) + 2.03345e-06*V(VREF)*V(V_SUPPLY) + 2.03345e-06*V(VREF)*V(MOST_POS) + -5.40289e-06*V(VREF)*V(EN_LDO) + -8.8571e-06*V(VREF)*meta_corner + -1.23736e-08*V(VREF)*meta_temp + 2.03345e-06*V(VREF)*meta_vsup_max + -1.8512e-06*V(FUN_DC)*V(FUN_DC) + -1.8512e-06*V(FUN_DC)*V(V_SUPPLY) + -1.8512e-06*V(FUN_DC)*V(MOST_POS) + 1.45247e-05*V(FUN_DC)*V(EN_LDO) + 4.03487e-06*V(FUN_DC)*meta_corner + 3.65698e-09*V(FUN_DC)*meta_temp + -1.8512e-06*V(FUN_DC)*meta_vsup_max + -1.8512e-06*V(V_SUPPLY)*V(V_SUPPLY) + -1.8512e-06*V(V_SUPPLY)*V(MOST_POS) + 1.45247e-05*V(V_SUPPLY)*V(EN_LDO) + 4.03487e-06*V(V_SUPPLY)*meta_corner + 3.78617e-09*V(V_SUPPLY)*meta_temp + -1.8512e-06*V(V_SUPPLY)*meta_vsup_max + -1.8512e-06*V(MOST_POS)*V(MOST_POS) + 1.45247e-05*V(MOST_POS)*V(EN_LDO) + 4.03487e-06*V(MOST_POS)*meta_corner + 5.19688e-09*V(MOST_POS)*meta_temp + -1.85121e-06*V(MOST_POS)*meta_vsup_max + -3.85921e-05*V(EN_LDO)*V(EN_LDO) + -6.3265e-05*V(EN_LDO)*meta_corner + -8.70307e-08*V(EN_LDO)*meta_temp + 1.45247e-05*V(EN_LDO)*meta_vsup_max + -0.00117991*meta_corner*meta_corner + -4.24782e-08*meta_corner*meta_temp + 4.03487e-06*meta_corner*meta_vsup_max + 7.98665e-10*meta_temp*meta_temp + 3.89653e-09*meta_temp*meta_vsup_max + -1.8512e-06*meta_vsup_max*meta_vsup_max + 0.854853*ddt(V(VPWR)) + 2.97276*ddt(V(VREF)) + 0.854853*ddt(V(FUN_DC)) + 0.854853*ddt(V(V_SUPPLY)) + 0.854853*ddt(V(MOST_POS)) + -3.63934*ddt(V(EN_LDO)) + -0.00102926*idt(V(VPWR)) + 0.000533665*idt(V(VREF)) + -0.00102926*idt(V(FUN_DC)) + -0.00102926*idt(V(V_SUPPLY)) + -0.00102926*idt(V(MOST_POS)) + 0.00381199*idt(V(EN_LDO)) + -1.54368e-06;  // MOST_POS_I
                V(VDD_1V2) <+ 0.0197272*V(VPWR) + -0.00729202*V(VREF) + 0.0197272*V(FUN_DC) + 0.0197272*V(V_SUPPLY) + 0.0197272*V(MOST_POS) + -0.0520854*V(EN_LDO) + 0.30338*meta_corner + 0.000406596*meta_temp + 0.0197272*meta_vsup_max + -0.0175284*V(VPWR)*V(VPWR) + 0.0138091*V(VPWR)*V(VREF) + -0.0175284*V(VPWR)*V(FUN_DC) + -0.0175284*V(VPWR)*V(V_SUPPLY) + -0.0175284*V(VPWR)*V(MOST_POS) + 0.0986362*V(VPWR)*V(EN_LDO) + 0.117649*V(VPWR)*meta_corner + -0.000346854*V(VPWR)*meta_temp + -0.0175284*V(VPWR)*meta_vsup_max + -0.00510437*V(VREF)*V(VREF) + 0.0138091*V(VREF)*V(FUN_DC) + 0.0138091*V(VREF)*V(V_SUPPLY) + 0.0138091*V(VREF)*V(MOST_POS) + -0.0364598*V(VREF)*V(EN_LDO) + 0.212366*V(VREF)*meta_corner + 0.000284615*V(VREF)*meta_temp + 0.0138091*V(VREF)*meta_vsup_max + -0.0175284*V(FUN_DC)*V(FUN_DC) + -0.0175284*V(FUN_DC)*V(V_SUPPLY) + -0.0175284*V(FUN_DC)*V(MOST_POS) + 0.0986362*V(FUN_DC)*V(EN_LDO) + 0.117649*V(FUN_DC)*meta_corner + -0.000346903*V(FUN_DC)*meta_temp + -0.0175284*V(FUN_DC)*meta_vsup_max + -0.0175284*V(V_SUPPLY)*V(V_SUPPLY) + -0.0175284*V(V_SUPPLY)*V(MOST_POS) + 0.0986362*V(V_SUPPLY)*V(EN_LDO) + 0.117649*V(V_SUPPLY)*meta_corner + -0.000346934*V(V_SUPPLY)*meta_temp + -0.0175284*V(V_SUPPLY)*meta_vsup_max + -0.0175284*V(MOST_POS)*V(MOST_POS) + 0.0986362*V(MOST_POS)*V(EN_LDO) + 0.117649*V(MOST_POS)*meta_corner + -0.000347068*V(MOST_POS)*meta_temp + -0.0175284*V(MOST_POS)*meta_vsup_max + -0.260427*V(EN_LDO)*V(EN_LDO) + 1.5169*V(EN_LDO)*meta_corner + 0.00203293*V(EN_LDO)*meta_temp + 0.0986362*V(EN_LDO)*meta_vsup_max + 22.4805*meta_corner*meta_corner + 0.00223713*meta_corner*meta_temp + 0.117649*meta_corner*meta_vsup_max + -7.08153e-06*meta_temp*meta_temp + -0.000346926*meta_temp*meta_vsup_max + -0.0175284*meta_vsup_max*meta_vsup_max + 54.514*ddt(V(VPWR)) + -296.89*ddt(V(VREF)) + 54.514*ddt(V(FUN_DC)) + 54.514*ddt(V(V_SUPPLY)) + 54.514*ddt(V(MOST_POS)) + -186.973*ddt(V(EN_LDO)) + 7.56663*idt(V(VPWR)) + -4.5706*idt(V(VREF)) + 7.56663*idt(V(FUN_DC)) + 7.56663*idt(V(V_SUPPLY)) + 7.56663*idt(V(MOST_POS)) + -32.6471*idt(V(EN_LDO)) + -0.0104171;
                I(VPWR, GND) <+ 0.000318944*V(VPWR) + -0.000101145*V(VREF) + 0.000318939*V(FUN_DC) + 0.000318944*V(V_SUPPLY) + 0.000318944*V(MOST_POS) + -0.000722419*V(EN_LDO) + -0.00130514*meta_corner + -1.47836e-06*meta_temp + 0.000318944*meta_vsup_max + -0.000249127*V(VPWR)*V(VPWR) + 0.000223261*V(VPWR)*V(VREF) + -0.000249127*V(VPWR)*V(FUN_DC) + -0.000249127*V(VPWR)*V(V_SUPPLY) + -0.000249127*V(VPWR)*V(MOST_POS) + 0.00159472*V(VPWR)*V(EN_LDO) + -0.000722338*V(VPWR)*meta_corner + 3.77625e-06*V(VPWR)*meta_temp + -0.000249127*V(VPWR)*meta_vsup_max + -7.07971e-05*V(VREF)*V(VREF) + 0.000223261*V(VREF)*V(FUN_DC) + 0.000223261*V(VREF)*V(V_SUPPLY) + 0.000223261*V(VREF)*V(MOST_POS) + -0.000505693*V(VREF)*V(EN_LDO) + -0.000913596*V(VREF)*meta_corner + -1.03477e-06*V(VREF)*meta_temp + 0.000223261*V(VREF)*meta_vsup_max + -0.000249127*V(FUN_DC)*V(FUN_DC) + -0.000249127*V(FUN_DC)*V(V_SUPPLY) + -0.000249127*V(FUN_DC)*V(MOST_POS) + 0.00159472*V(FUN_DC)*V(EN_LDO) + -0.000722338*V(FUN_DC)*meta_corner + 3.77076e-06*V(FUN_DC)*meta_temp + -0.000249127*V(FUN_DC)*meta_vsup_max + -0.000249127*V(V_SUPPLY)*V(V_SUPPLY) + -0.000249127*V(V_SUPPLY)*V(MOST_POS) + 0.00159472*V(V_SUPPLY)*V(EN_LDO) + -0.000722338*V(V_SUPPLY)*meta_corner + 3.76779e-06*V(V_SUPPLY)*meta_temp + -0.000249127*V(V_SUPPLY)*meta_vsup_max + -0.000249127*V(MOST_POS)*V(MOST_POS) + 0.00159472*V(MOST_POS)*V(EN_LDO) + -0.000722338*V(MOST_POS)*meta_corner + 3.75262e-06*V(MOST_POS)*meta_temp + -0.000249127*V(MOST_POS)*meta_vsup_max + -0.0036121*V(EN_LDO)*V(EN_LDO) + -0.00652569*V(EN_LDO)*meta_corner + -7.39722e-06*V(EN_LDO)*meta_temp + 0.00159472*V(EN_LDO)*meta_vsup_max + -0.162319*meta_corner*meta_corner + -0.000175656*meta_corner*meta_temp + -0.000722338*meta_corner*meta_vsup_max + 9.38132e-08*meta_temp*meta_temp + 3.76828e-06*meta_temp*meta_vsup_max + -0.000249127*meta_vsup_max*meta_vsup_max + 3.80676*ddt(V(VPWR)) + -32.9898*ddt(V(VREF)) + 3.80676*ddt(V(FUN_DC)) + 3.80676*ddt(V(V_SUPPLY)) + 3.80676*ddt(V(MOST_POS)) + -11.3978*ddt(V(EN_LDO)) + -0.0926189*idt(V(VPWR)) + 0.0558015*idt(V(VREF)) + -0.0926189*idt(V(FUN_DC)) + -0.0926189*idt(V(V_SUPPLY)) + -0.0926189*idt(V(MOST_POS)) + 0.398582*idt(V(EN_LDO)) + -0.000144484;  // VPWR_I
                I(V_SUPPLY, GND) <+ -7.82281e-09*V(VPWR) + 2.50189e-09*V(VREF) + -7.82281e-09*V(FUN_DC) + -7.82281e-09*V(V_SUPPLY) + -7.82281e-09*V(MOST_POS) + 1.78707e-08*V(EN_LDO) + -3.50487e-08*meta_corner + -6.03684e-10*meta_temp + -7.82281e-09*meta_vsup_max + 7.66983e-09*V(VPWR)*V(VPWR) + -5.47597e-09*V(VPWR)*V(VREF) + 7.66983e-09*V(VPWR)*V(FUN_DC) + 7.66983e-09*V(VPWR)*V(V_SUPPLY) + 7.66983e-09*V(VPWR)*V(MOST_POS) + -3.91141e-08*V(VPWR)*V(EN_LDO) + 1.61746e-08*V(VPWR)*meta_corner + 6.41534e-10*V(VPWR)*meta_temp + 7.66983e-09*V(VPWR)*meta_vsup_max + 1.75132e-09*V(VREF)*V(VREF) + -5.47597e-09*V(VREF)*V(FUN_DC) + -5.47597e-09*V(VREF)*V(V_SUPPLY) + -5.47597e-09*V(VREF)*V(MOST_POS) + 1.25095e-08*V(VREF)*V(EN_LDO) + -2.45341e-08*V(VREF)*meta_corner + -4.22579e-10*V(VREF)*meta_temp + -5.47597e-09*V(VREF)*meta_vsup_max + 7.66983e-09*V(FUN_DC)*V(FUN_DC) + 7.66983e-09*V(FUN_DC)*V(V_SUPPLY) + 7.66983e-09*V(FUN_DC)*V(MOST_POS) + -3.91141e-08*V(FUN_DC)*V(EN_LDO) + 1.61746e-08*V(FUN_DC)*meta_corner + 6.41534e-10*V(FUN_DC)*meta_temp + 7.66983e-09*V(FUN_DC)*meta_vsup_max + 7.66983e-09*V(V_SUPPLY)*V(V_SUPPLY) + 7.66983e-09*V(V_SUPPLY)*V(MOST_POS) + -3.91141e-08*V(V_SUPPLY)*V(EN_LDO) + 1.61746e-08*V(V_SUPPLY)*meta_corner + 6.41535e-10*V(V_SUPPLY)*meta_temp + 7.66983e-09*V(V_SUPPLY)*meta_vsup_max + 7.66983e-09*V(MOST_POS)*V(MOST_POS) + -3.91141e-08*V(MOST_POS)*V(EN_LDO) + 1.61746e-08*V(MOST_POS)*meta_corner + 6.41537e-10*V(MOST_POS)*meta_temp + 7.66983e-09*V(MOST_POS)*meta_vsup_max + 8.93533e-08*V(EN_LDO)*V(EN_LDO) + -1.75243e-07*V(EN_LDO)*meta_corner + -3.01842e-09*V(EN_LDO)*meta_temp + -3.91141e-08*V(EN_LDO)*meta_vsup_max + -2.34933e-06*meta_corner*meta_corner + 1.31669e-10*meta_corner*meta_temp + 1.61746e-08*meta_corner*meta_vsup_max + 6.41535e-10*meta_temp*meta_vsup_max + 7.66983e-09*meta_vsup_max*meta_vsup_max + -3.94105e-06*ddt(V(VPWR)) + 3.38268e-06*ddt(V(VREF)) + -3.94105e-06*ddt(V(FUN_DC)) + -3.94105e-06*ddt(V(V_SUPPLY)) + -3.94105e-06*ddt(V(MOST_POS)) + 1.63176e-05*ddt(V(EN_LDO)) + -1.14002e-06*idt(V(VPWR)) + 6.60091e-07*idt(V(VREF)) + -1.14002e-06*idt(V(FUN_DC)) + -1.14002e-06*idt(V(V_SUPPLY)) + -1.14002e-06*idt(V(MOST_POS)) + 4.71493e-06*idt(V(EN_LDO)) + 3.57413e-09;  // V_SUPPLY_I
            end
            REGULATION_8: begin
                I(FUN_DC, GND) <+ 7.13388e-07*V(VPWR) + -2.32517e-07*V(VREF) + 7.13388e-07*V(FUN_DC) + 7.13388e-07*V(V_SUPPLY) + 7.13388e-07*V(MOST_POS) + -1.66084e-06*V(EN_LDO) + 3.12899e-06*meta_corner + -1.1199e-08*meta_temp + 7.13388e-07*meta_vsup_max + -6.66018e-07*V(VPWR)*V(VPWR) + 4.99372e-07*V(VPWR)*V(VREF) + -6.66018e-07*V(VPWR)*V(FUN_DC) + -6.66018e-07*V(VPWR)*V(V_SUPPLY) + -6.66018e-07*V(VPWR)*V(MOST_POS) + 3.56694e-06*V(VPWR)*V(EN_LDO) + -3.10235e-06*V(VPWR)*meta_corner + 1.057e-08*V(VPWR)*meta_temp + -6.66018e-07*V(VPWR)*meta_vsup_max + -1.62762e-07*V(VREF)*V(VREF) + 4.99372e-07*V(VREF)*V(FUN_DC) + 4.99372e-07*V(VREF)*V(V_SUPPLY) + 4.99372e-07*V(VREF)*V(MOST_POS) + -1.16258e-06*V(VREF)*V(EN_LDO) + 2.19029e-06*V(VREF)*meta_corner + -7.83924e-09*V(VREF)*meta_temp + 4.99372e-07*V(VREF)*meta_vsup_max + -6.66018e-07*V(FUN_DC)*V(FUN_DC) + -6.66018e-07*V(FUN_DC)*V(V_SUPPLY) + -6.66018e-07*V(FUN_DC)*V(MOST_POS) + 3.56694e-06*V(FUN_DC)*V(EN_LDO) + -3.10235e-06*V(FUN_DC)*meta_corner + 1.057e-08*V(FUN_DC)*meta_temp + -6.66018e-07*V(FUN_DC)*meta_vsup_max + -6.66018e-07*V(V_SUPPLY)*V(V_SUPPLY) + -6.66018e-07*V(V_SUPPLY)*V(MOST_POS) + 3.56694e-06*V(V_SUPPLY)*V(EN_LDO) + -3.10235e-06*V(V_SUPPLY)*meta_corner + 1.05699e-08*V(V_SUPPLY)*meta_temp + -6.66018e-07*V(V_SUPPLY)*meta_vsup_max + -6.66018e-07*V(MOST_POS)*V(MOST_POS) + 3.56694e-06*V(MOST_POS)*V(EN_LDO) + -3.10235e-06*V(MOST_POS)*meta_corner + 1.057e-08*V(MOST_POS)*meta_temp + -6.66018e-07*V(MOST_POS)*meta_vsup_max + -8.30418e-06*V(EN_LDO)*V(EN_LDO) + 1.5645e-05*V(EN_LDO)*meta_corner + -5.59903e-08*V(EN_LDO)*meta_temp + 3.56694e-06*V(EN_LDO)*meta_vsup_max + 2.96253e-06*meta_corner*meta_corner + -6.59245e-08*meta_corner*meta_temp + -3.10235e-06*meta_corner*meta_vsup_max + 2.92162e-10*meta_temp*meta_temp + 1.05699e-08*meta_temp*meta_vsup_max + -6.66018e-07*meta_vsup_max*meta_vsup_max + 4.88336e-08*ddt(V(VPWR)) + -0.000511052*ddt(V(VREF)) + 4.88336e-08*ddt(V(FUN_DC)) + 4.88336e-08*ddt(V(V_SUPPLY)) + 4.88336e-08*ddt(V(MOST_POS)) + 4.67144e-05*ddt(V(EN_LDO)) + 1.13744e-05*idt(V(VPWR)) + -6.69421e-06*idt(V(VREF)) + 1.13744e-05*idt(V(FUN_DC)) + 1.13744e-05*idt(V(V_SUPPLY)) + 1.13744e-05*idt(V(MOST_POS)) + -4.78158e-05*idt(V(EN_LDO)) + -3.32167e-07;  // FUN_DC_I
                I(MOST_POS, GND) <+ 9.07705e-06*V(VPWR) + -3.30756e-06*V(VREF) + 9.0769e-06*V(FUN_DC) + 9.07691e-06*V(V_SUPPLY) + 9.07691e-06*V(MOST_POS) + -2.36231e-05*V(EN_LDO) + -1.72221e-05*meta_corner + 5.03946e-08*meta_temp + 9.07691e-06*meta_vsup_max + -7.54058e-06*V(VPWR)*V(VPWR) + 6.35399e-06*V(VPWR)*V(VREF) + -7.54058e-06*V(VPWR)*V(FUN_DC) + -7.54058e-06*V(VPWR)*V(V_SUPPLY) + -7.54058e-06*V(VPWR)*V(MOST_POS) + 4.53864e-05*V(VPWR)*V(EN_LDO) + 3.25139e-05*V(VPWR)*meta_corner + -9.82905e-08*V(VPWR)*meta_temp + -7.54058e-06*V(VPWR)*meta_vsup_max + -2.31504e-06*V(VREF)*V(VREF) + 6.35399e-06*V(VREF)*V(FUN_DC) + 6.35399e-06*V(VREF)*V(V_SUPPLY) + 6.35399e-06*V(VREF)*V(MOST_POS) + -1.65362e-05*V(VREF)*V(EN_LDO) + -1.20555e-05*V(VREF)*meta_corner + 3.50579e-08*V(VREF)*meta_temp + 6.35399e-06*V(VREF)*meta_vsup_max + -7.54058e-06*V(FUN_DC)*V(FUN_DC) + -7.54058e-06*V(FUN_DC)*V(V_SUPPLY) + -7.54058e-06*V(FUN_DC)*V(MOST_POS) + 4.53864e-05*V(FUN_DC)*V(EN_LDO) + 3.25139e-05*V(FUN_DC)*meta_corner + -9.82586e-08*V(FUN_DC)*meta_temp + -7.54058e-06*V(FUN_DC)*meta_vsup_max + -7.54058e-06*V(V_SUPPLY)*V(V_SUPPLY) + -7.54058e-06*V(V_SUPPLY)*V(MOST_POS) + 4.53864e-05*V(V_SUPPLY)*V(EN_LDO) + 3.25139e-05*V(V_SUPPLY)*meta_corner + -9.82252e-08*V(V_SUPPLY)*meta_temp + -7.54058e-06*V(V_SUPPLY)*meta_vsup_max + -7.54058e-06*V(MOST_POS)*V(MOST_POS) + 4.53864e-05*V(MOST_POS)*V(EN_LDO) + 3.25139e-05*V(MOST_POS)*meta_corner + -9.83588e-08*V(MOST_POS)*meta_temp + -7.54058e-06*V(MOST_POS)*meta_vsup_max + -0.000118113*V(EN_LDO)*V(EN_LDO) + -8.61108e-05*V(EN_LDO)*meta_corner + 2.37225e-07*V(EN_LDO)*meta_temp + 4.53864e-05*V(EN_LDO)*meta_vsup_max + 0.000580969*meta_corner*meta_corner + -2.06696e-06*meta_corner*meta_temp + 3.25139e-05*meta_corner*meta_vsup_max + 6.31888e-09*meta_temp*meta_temp + -9.80401e-08*meta_temp*meta_vsup_max + -7.54058e-06*meta_vsup_max*meta_vsup_max + 0.348667*ddt(V(VPWR)) + 1.64772*ddt(V(VREF)) + 0.348667*ddt(V(FUN_DC)) + 0.348667*ddt(V(V_SUPPLY)) + 0.348667*ddt(V(MOST_POS)) + -0.0634927*ddt(V(EN_LDO)) + -6.11992e-05*idt(V(VPWR)) + 3.28529e-05*idt(V(VREF)) + -6.11992e-05*idt(V(FUN_DC)) + -6.11992e-05*idt(V(V_SUPPLY)) + -6.11992e-05*idt(V(MOST_POS)) + 0.000234684*idt(V(EN_LDO)) + -4.72483e-06;  // MOST_POS_I
                V(VDD_1V2) <+ 0.0255206*V(VPWR) + -0.00664901*V(VREF) + 0.0255205*V(FUN_DC) + 0.0255205*V(V_SUPPLY) + 0.0255205*V(MOST_POS) + -0.0474916*V(EN_LDO) + 0.212847*meta_corner + 0.000865128*meta_temp + 0.0255205*meta_vsup_max + -0.0278512*V(VPWR)*V(VPWR) + 0.0178644*V(VPWR)*V(VREF) + -0.0278512*V(VPWR)*V(FUN_DC) + -0.0278512*V(VPWR)*V(V_SUPPLY) + -0.0278512*V(VPWR)*V(MOST_POS) + 0.127603*V(VPWR)*V(EN_LDO) + 0.202672*V(VPWR)*meta_corner + -0.000764203*V(VPWR)*meta_temp + -0.0278512*V(VPWR)*meta_vsup_max + -0.00465416*V(VREF)*V(VREF) + 0.0178644*V(VREF)*V(FUN_DC) + 0.0178644*V(VREF)*V(V_SUPPLY) + 0.0178644*V(VREF)*V(MOST_POS) + -0.0332441*V(VREF)*V(EN_LDO) + 0.148993*V(VREF)*meta_corner + 0.000605466*V(VREF)*meta_temp + 0.0178644*V(VREF)*meta_vsup_max + -0.0278512*V(FUN_DC)*V(FUN_DC) + -0.0278512*V(FUN_DC)*V(V_SUPPLY) + -0.0278512*V(FUN_DC)*V(MOST_POS) + 0.127603*V(FUN_DC)*V(EN_LDO) + 0.202672*V(FUN_DC)*meta_corner + -0.000764185*V(FUN_DC)*meta_temp + -0.0278512*V(FUN_DC)*meta_vsup_max + -0.0278512*V(V_SUPPLY)*V(V_SUPPLY) + -0.0278512*V(V_SUPPLY)*V(MOST_POS) + 0.127603*V(V_SUPPLY)*V(EN_LDO) + 0.202672*V(V_SUPPLY)*meta_corner + -0.000764166*V(V_SUPPLY)*meta_temp + -0.0278512*V(V_SUPPLY)*meta_vsup_max + -0.0278512*V(MOST_POS)*V(MOST_POS) + 0.127603*V(MOST_POS)*V(EN_LDO) + 0.202672*V(MOST_POS)*meta_corner + -0.000764241*V(MOST_POS)*meta_temp + -0.0278512*V(MOST_POS)*meta_vsup_max + -0.237456*V(EN_LDO)*V(EN_LDO) + 1.06423*V(EN_LDO)*meta_corner + 0.00431725*V(EN_LDO)*meta_temp + 0.127603*V(EN_LDO)*meta_vsup_max + 22.1234*meta_corner*meta_corner + 0.00485147*meta_corner*meta_temp + 0.202672*meta_corner*meta_vsup_max + -1.75144e-05*meta_temp*meta_temp + -0.000764063*meta_temp*meta_vsup_max + -0.0278512*meta_vsup_max*meta_vsup_max + 20.0637*ddt(V(VPWR)) + 922.539*ddt(V(VREF)) + 20.0637*ddt(V(FUN_DC)) + 20.0637*ddt(V(V_SUPPLY)) + 20.0637*ddt(V(MOST_POS)) + 12.4159*ddt(V(EN_LDO)) + 23.0471*idt(V(VPWR)) + -14.094*idt(V(VREF)) + 23.0471*idt(V(FUN_DC)) + 23.0471*idt(V(V_SUPPLY)) + 23.0471*idt(V(MOST_POS)) + -100.671*idt(V(EN_LDO)) + -0.00949844;
                I(VPWR, GND) <+ 0.000470883*V(VPWR) + -0.000161867*V(VREF) + 0.00047088*V(FUN_DC) + 0.00047088*V(V_SUPPLY) + 0.00047088*V(MOST_POS) + -0.00115614*V(EN_LDO) + -0.00103727*meta_corner + -2.88015e-06*meta_temp + 0.00047088*meta_vsup_max + -0.000367987*V(VPWR)*V(VPWR) + 0.000329619*V(VPWR)*V(VREF) + -0.000367987*V(VPWR)*V(FUN_DC) + -0.000367987*V(VPWR)*V(V_SUPPLY) + -0.000367987*V(VPWR)*V(MOST_POS) + 0.00235444*V(VPWR)*V(EN_LDO) + -0.00107985*V(VPWR)*meta_corner + 4.81279e-06*V(VPWR)*meta_temp + -0.000367987*V(VPWR)*meta_vsup_max + -0.000113302*V(VREF)*V(VREF) + 0.000329619*V(VREF)*V(FUN_DC) + 0.000329619*V(VREF)*V(V_SUPPLY) + 0.000329619*V(VREF)*V(MOST_POS) + -0.000809301*V(VREF)*V(EN_LDO) + -0.000726087*V(VREF)*meta_corner + -2.02035e-06*V(VREF)*meta_temp + 0.000329619*V(VREF)*meta_vsup_max + -0.000367987*V(FUN_DC)*V(FUN_DC) + -0.000367987*V(FUN_DC)*V(V_SUPPLY) + -0.000367987*V(FUN_DC)*V(MOST_POS) + 0.00235444*V(FUN_DC)*V(EN_LDO) + -0.00107985*V(FUN_DC)*meta_corner + 4.81336e-06*V(FUN_DC)*meta_temp + -0.000367987*V(FUN_DC)*meta_vsup_max + -0.000367987*V(V_SUPPLY)*V(V_SUPPLY) + -0.000367987*V(V_SUPPLY)*V(MOST_POS) + 0.00235444*V(V_SUPPLY)*V(EN_LDO) + -0.00107985*V(V_SUPPLY)*meta_corner + 4.81405e-06*V(V_SUPPLY)*meta_temp + -0.000367987*V(V_SUPPLY)*meta_vsup_max + -0.000367987*V(MOST_POS)*V(MOST_POS) + 0.00235444*V(MOST_POS)*V(EN_LDO) + -0.00107985*V(MOST_POS)*meta_corner + 4.81147e-06*V(MOST_POS)*meta_temp + -0.000367987*V(MOST_POS)*meta_vsup_max + -0.00578067*V(EN_LDO)*V(EN_LDO) + -0.00518634*V(EN_LDO)*meta_corner + -1.469e-05*V(EN_LDO)*meta_temp + 0.00235444*V(EN_LDO)*meta_vsup_max + -0.170204*meta_corner*meta_corner + -0.000204281*meta_corner*meta_temp + -0.00107985*meta_corner*meta_vsup_max + 1.44047e-07*meta_temp*meta_temp + 4.81755e-06*meta_temp*meta_vsup_max + -0.000367987*meta_vsup_max*meta_vsup_max + 2.08483*ddt(V(VPWR)) + 31.636*ddt(V(VREF)) + 2.08483*ddt(V(FUN_DC)) + 2.08483*ddt(V(V_SUPPLY)) + 2.08483*ddt(V(MOST_POS)) + -1.5347*ddt(V(EN_LDO)) + -0.118456*idt(V(VPWR)) + 0.072875*idt(V(VREF)) + -0.118456*idt(V(FUN_DC)) + -0.118456*idt(V(V_SUPPLY)) + -0.118456*idt(V(MOST_POS)) + 0.520536*idt(V(EN_LDO)) + -0.000231233;  // VPWR_I
                I(V_SUPPLY, GND) <+ -7.61843e-09*V(VPWR) + 2.54321e-09*V(VREF) + -7.61843e-09*V(FUN_DC) + -7.61843e-09*V(V_SUPPLY) + -7.61843e-09*V(MOST_POS) + 1.81658e-08*V(EN_LDO) + -1.4534e-08*meta_corner + -4.34993e-10*meta_temp + -7.61843e-09*meta_vsup_max + 7.15044e-09*V(VPWR)*V(VPWR) + -5.3329e-09*V(VPWR)*V(VREF) + 7.15044e-09*V(VPWR)*V(FUN_DC) + 7.15044e-09*V(VPWR)*V(V_SUPPLY) + 7.15044e-09*V(VPWR)*V(MOST_POS) + -3.80921e-08*V(VPWR)*V(EN_LDO) + -1.07007e-10*V(VPWR)*meta_corner + 4.56637e-10*V(VPWR)*meta_temp + 7.15044e-09*V(VPWR)*meta_vsup_max + 1.78024e-09*V(VREF)*V(VREF) + -5.3329e-09*V(VREF)*V(FUN_DC) + -5.3329e-09*V(VREF)*V(V_SUPPLY) + -5.3329e-09*V(VREF)*V(MOST_POS) + 1.2716e-08*V(VREF)*V(EN_LDO) + -1.01738e-08*V(VREF)*meta_corner + -3.04495e-10*V(VREF)*meta_temp + -5.3329e-09*V(VREF)*meta_vsup_max + 7.15044e-09*V(FUN_DC)*V(FUN_DC) + 7.15044e-09*V(FUN_DC)*V(V_SUPPLY) + 7.15044e-09*V(FUN_DC)*V(MOST_POS) + -3.80921e-08*V(FUN_DC)*V(EN_LDO) + -1.07007e-10*V(FUN_DC)*meta_corner + 4.56637e-10*V(FUN_DC)*meta_temp + 7.15044e-09*V(FUN_DC)*meta_vsup_max + 7.15044e-09*V(V_SUPPLY)*V(V_SUPPLY) + 7.15044e-09*V(V_SUPPLY)*V(MOST_POS) + -3.80921e-08*V(V_SUPPLY)*V(EN_LDO) + -1.07007e-10*V(V_SUPPLY)*meta_corner + 4.56637e-10*V(V_SUPPLY)*meta_temp + 7.15044e-09*V(V_SUPPLY)*meta_vsup_max + 7.15044e-09*V(MOST_POS)*V(MOST_POS) + -3.80921e-08*V(MOST_POS)*V(EN_LDO) + -1.07007e-10*V(MOST_POS)*meta_corner + 4.56637e-10*V(MOST_POS)*meta_temp + 7.15044e-09*V(MOST_POS)*meta_vsup_max + 9.08288e-08*V(EN_LDO)*V(EN_LDO) + -7.26699e-08*V(EN_LDO)*meta_corner + -2.17495e-09*V(EN_LDO)*meta_temp + -3.80921e-08*V(EN_LDO)*meta_vsup_max + -1.72545e-06*meta_corner*meta_corner + -4.81155e-10*meta_corner*meta_temp + -1.07007e-10*meta_corner*meta_vsup_max + 4.56637e-10*meta_temp*meta_vsup_max + 7.15044e-09*meta_vsup_max*meta_vsup_max + -7.10199e-07*ddt(V(VPWR)) + -1.7655e-06*ddt(V(VREF)) + -7.10199e-07*ddt(V(FUN_DC)) + -7.10199e-07*ddt(V(V_SUPPLY)) + -7.10199e-07*ddt(V(MOST_POS)) + 2.71671e-06*ddt(V(EN_LDO)) + -4.24109e-07*idt(V(VPWR)) + 2.36184e-07*idt(V(VREF)) + -4.24109e-07*idt(V(FUN_DC)) + -4.24109e-07*idt(V(V_SUPPLY)) + -4.24109e-07*idt(V(MOST_POS)) + 1.68703e-06*idt(V(EN_LDO)) + 3.63315e-09;  // V_SUPPLY_I
            end
            REGULATION_9: begin
                I(FUN_DC, GND) <+ 1.72883e-07*V(VPWR) + -3.94165e-08*V(VREF) + 1.72858e-07*V(FUN_DC) + 1.72882e-07*V(V_SUPPLY) + 1.72883e-07*V(MOST_POS) + -2.79522e-07*V(EN_LDO) + 2.4302e-06*meta_corner + -5.76496e-09*meta_temp + 1.72882e-07*meta_vsup_max + -2.06487e-07*V(VPWR)*V(VPWR) + 1.21017e-07*V(VPWR)*V(VREF) + -2.06487e-07*V(VPWR)*V(FUN_DC) + -2.06487e-07*V(VPWR)*V(V_SUPPLY) + -2.06487e-07*V(VPWR)*V(MOST_POS) + 8.64407e-07*V(VPWR)*V(EN_LDO) + -2.48961e-06*V(VPWR)*meta_corner + 5.44992e-09*V(VPWR)*meta_temp + -2.06487e-07*V(VPWR)*meta_vsup_max + -2.73932e-08*V(VREF)*V(VREF) + 1.21017e-07*V(VREF)*V(FUN_DC) + 1.21017e-07*V(VREF)*V(V_SUPPLY) + 1.21017e-07*V(VREF)*V(MOST_POS) + -1.95666e-07*V(VREF)*V(EN_LDO) + 1.70114e-06*V(VREF)*meta_corner + -4.09588e-09*V(VREF)*meta_temp + 1.21017e-07*V(VREF)*meta_vsup_max + -2.06487e-07*V(FUN_DC)*V(FUN_DC) + -2.06487e-07*V(FUN_DC)*V(V_SUPPLY) + -2.06487e-07*V(FUN_DC)*V(MOST_POS) + 8.64407e-07*V(FUN_DC)*V(EN_LDO) + -2.48961e-06*V(FUN_DC)*meta_corner + 5.45224e-09*V(FUN_DC)*meta_temp + -2.06487e-07*V(FUN_DC)*meta_vsup_max + -2.06487e-07*V(V_SUPPLY)*V(V_SUPPLY) + -2.06487e-07*V(V_SUPPLY)*V(MOST_POS) + 8.64407e-07*V(V_SUPPLY)*V(EN_LDO) + -2.48961e-06*V(V_SUPPLY)*meta_corner + 5.452e-09*V(V_SUPPLY)*meta_temp + -2.06487e-07*V(V_SUPPLY)*meta_vsup_max + -2.06487e-07*V(MOST_POS)*V(MOST_POS) + 8.64407e-07*V(MOST_POS)*V(EN_LDO) + -2.48961e-06*V(MOST_POS)*meta_corner + 5.46428e-09*V(MOST_POS)*meta_temp + -2.06487e-07*V(MOST_POS)*meta_vsup_max + -1.39761e-06*V(EN_LDO)*V(EN_LDO) + 1.2151e-05*V(EN_LDO)*meta_corner + -2.89973e-08*V(EN_LDO)*meta_temp + 8.64407e-07*V(EN_LDO)*meta_vsup_max + -2.16344e-07*meta_corner*meta_corner + -4.16056e-08*meta_corner*meta_temp + -2.4896e-06*meta_corner*meta_vsup_max + 1.98818e-10*meta_temp*meta_temp + 5.44888e-09*meta_temp*meta_vsup_max + -2.06487e-07*meta_vsup_max*meta_vsup_max + 0.000107099*ddt(V(VPWR)) + 0.0479538*ddt(V(VREF)) + 0.000107099*ddt(V(FUN_DC)) + 0.000107099*ddt(V(V_SUPPLY)) + 0.000107099*ddt(V(MOST_POS)) + 0.00157546*ddt(V(EN_LDO)) + 6.65483e-05*idt(V(VPWR)) + -3.61473e-05*idt(V(VREF)) + 6.65483e-05*idt(V(FUN_DC)) + 6.65483e-05*idt(V(V_SUPPLY)) + 6.65483e-05*idt(V(MOST_POS)) + -0.000258208*idt(V(EN_LDO)) + -5.59043e-08;  // FUN_DC_I
                I(MOST_POS, GND) <+ -3.64545e-08*V(VPWR) + 9.536e-08*V(VREF) + -3.63491e-08*V(FUN_DC) + -3.64507e-08*V(V_SUPPLY) + -3.64555e-08*V(MOST_POS) + 6.72738e-07*V(EN_LDO) + -1.71246e-06*meta_corner + -4.78156e-08*meta_temp + -3.64517e-08*meta_vsup_max + -2.6913e-06*V(VPWR)*V(VPWR) + -2.55143e-08*V(VPWR)*V(VREF) + -2.6913e-06*V(VPWR)*V(FUN_DC) + -2.6913e-06*V(VPWR)*V(V_SUPPLY) + -2.6913e-06*V(VPWR)*V(MOST_POS) + -1.82246e-07*V(VPWR)*V(EN_LDO) + -2.75488e-05*V(VPWR)*meta_corner + 2.86158e-08*V(VPWR)*meta_temp + -2.6913e-06*V(VPWR)*meta_vsup_max + 6.59284e-08*V(VREF)*V(VREF) + -2.55143e-08*V(VREF)*V(FUN_DC) + -2.55143e-08*V(VREF)*V(V_SUPPLY) + -2.55143e-08*V(VREF)*V(MOST_POS) + 4.70918e-07*V(VREF)*V(EN_LDO) + -1.19872e-06*V(VREF)*meta_corner + -3.31852e-08*V(VREF)*meta_temp + -2.55143e-08*V(VREF)*meta_vsup_max + -2.6913e-06*V(FUN_DC)*V(FUN_DC) + -2.6913e-06*V(FUN_DC)*V(V_SUPPLY) + -2.6913e-06*V(FUN_DC)*V(MOST_POS) + -1.82246e-07*V(FUN_DC)*V(EN_LDO) + -2.75488e-05*V(FUN_DC)*meta_corner + 2.86057e-08*V(FUN_DC)*meta_temp + -2.6913e-06*V(FUN_DC)*meta_vsup_max + -2.6913e-06*V(V_SUPPLY)*V(V_SUPPLY) + -2.6913e-06*V(V_SUPPLY)*V(MOST_POS) + -1.82246e-07*V(V_SUPPLY)*V(EN_LDO) + -2.75488e-05*V(V_SUPPLY)*meta_corner + 2.86069e-08*V(V_SUPPLY)*meta_temp + -2.6913e-06*V(V_SUPPLY)*meta_vsup_max + -2.6913e-06*V(MOST_POS)*V(MOST_POS) + -1.82246e-07*V(MOST_POS)*V(EN_LDO) + -2.75488e-05*V(MOST_POS)*meta_corner + 2.85552e-08*V(MOST_POS)*meta_temp + -2.6913e-06*V(MOST_POS)*meta_vsup_max + 3.36368e-06*V(EN_LDO)*V(EN_LDO) + -8.5623e-06*V(EN_LDO)*meta_corner + -2.38279e-07*V(EN_LDO)*meta_temp + -1.82246e-07*V(EN_LDO)*meta_vsup_max + -0.00311898*meta_corner*meta_corner + 5.18711e-07*meta_corner*meta_temp + -2.75488e-05*meta_corner*meta_vsup_max + -1.56537e-09*meta_temp*meta_temp + 2.86203e-08*meta_temp*meta_vsup_max + -2.6913e-06*meta_vsup_max*meta_vsup_max + 0.042609*ddt(V(VPWR)) + -0.199849*ddt(V(VREF)) + 0.042609*ddt(V(FUN_DC)) + 0.042609*ddt(V(V_SUPPLY)) + 0.042609*ddt(V(MOST_POS)) + 0.181927*ddt(V(EN_LDO)) + 0.00683354*idt(V(VPWR)) + -0.00167701*idt(V(VREF)) + 0.00683354*idt(V(FUN_DC)) + 0.00683354*idt(V(V_SUPPLY)) + 0.00683354*idt(V(MOST_POS)) + -0.0119786*idt(V(EN_LDO)) + 1.34547e-07;  // MOST_POS_I
                V(VDD_1V2) <+ 0.0313201*V(VPWR) + -0.0191812*V(VREF) + 0.0313229*V(FUN_DC) + 0.0313202*V(V_SUPPLY) + 0.0313201*V(MOST_POS) + -0.137237*V(EN_LDO) + 0.225745*meta_corner + 0.000633002*meta_temp + 0.0313202*meta_vsup_max + -0.00591227*V(VPWR)*V(VPWR) + 0.0219242*V(VPWR)*V(VREF) + -0.00591227*V(VPWR)*V(FUN_DC) + -0.00591227*V(VPWR)*V(V_SUPPLY) + -0.00591227*V(VPWR)*V(MOST_POS) + 0.156601*V(VPWR)*V(EN_LDO) + 0.147935*V(VPWR)*meta_corner + -0.000427288*V(VPWR)*meta_temp + -0.00591227*V(VPWR)*meta_vsup_max + -0.0134492*V(VREF)*V(VREF) + 0.0219242*V(VREF)*V(FUN_DC) + 0.0219242*V(VREF)*V(V_SUPPLY) + 0.0219242*V(VREF)*V(MOST_POS) + -0.0960658*V(VREF)*V(EN_LDO) + 0.158021*V(VREF)*meta_corner + 0.000449999*V(VREF)*meta_temp + 0.0219242*V(VREF)*meta_vsup_max + -0.00591227*V(FUN_DC)*V(FUN_DC) + -0.00591227*V(FUN_DC)*V(V_SUPPLY) + -0.00591227*V(FUN_DC)*V(MOST_POS) + 0.156601*V(FUN_DC)*V(EN_LDO) + 0.147935*V(FUN_DC)*meta_corner + -0.000427552*V(FUN_DC)*meta_temp + -0.00591227*V(FUN_DC)*meta_vsup_max + -0.00591227*V(V_SUPPLY)*V(V_SUPPLY) + -0.00591227*V(V_SUPPLY)*V(MOST_POS) + 0.156601*V(V_SUPPLY)*V(EN_LDO) + 0.147935*V(V_SUPPLY)*meta_corner + -0.000427524*V(V_SUPPLY)*meta_temp + -0.00591227*V(V_SUPPLY)*meta_vsup_max + -0.00591227*V(MOST_POS)*V(MOST_POS) + 0.156601*V(MOST_POS)*V(EN_LDO) + 0.147935*V(MOST_POS)*meta_corner + -0.000428913*V(MOST_POS)*meta_temp + -0.00591226*V(MOST_POS)*meta_vsup_max + -0.686185*V(EN_LDO)*V(EN_LDO) + 1.12872*V(EN_LDO)*meta_corner + 0.00318466*V(EN_LDO)*meta_temp + 0.156601*V(EN_LDO)*meta_vsup_max + 20.3404*meta_corner*meta_corner + 0.00958136*meta_corner*meta_temp + 0.147935*meta_corner*meta_vsup_max + -2.78032e-05*meta_temp*meta_temp + -0.000427173*meta_temp*meta_vsup_max + -0.00591227*meta_vsup_max*meta_vsup_max + 47.006*ddt(V(VPWR)) + -5412.21*ddt(V(VREF)) + 47.006*ddt(V(FUN_DC)) + 47.006*ddt(V(V_SUPPLY)) + 47.006*ddt(V(MOST_POS)) + 221.121*ddt(V(EN_LDO)) + -39.2965*idt(V(VPWR)) + 20.1542*idt(V(VREF)) + -39.2965*idt(V(FUN_DC)) + -39.2965*idt(V(V_SUPPLY)) + -39.2965*idt(V(MOST_POS)) + 143.96*idt(V(EN_LDO)) + -0.0274474;
                I(VPWR, GND) <+ -0.000203857*V(VPWR) + 0.000105581*V(VREF) + -0.000203862*V(FUN_DC) + -0.000203858*V(V_SUPPLY) + -0.000203857*V(MOST_POS) + 0.000754556*V(EN_LDO) + -0.00234818*meta_corner + 1.26125e-06*meta_temp + -0.000203858*meta_vsup_max + 0.000147559*V(VPWR)*V(VPWR) + -0.0001427*V(VPWR)*V(VREF) + 0.000147559*V(VPWR)*V(FUN_DC) + 0.000147559*V(VPWR)*V(V_SUPPLY) + 0.000147559*V(VPWR)*V(MOST_POS) + -0.00101929*V(VPWR)*V(EN_LDO) + 0.000431934*V(VPWR)*meta_corner + 9.86041e-07*V(VPWR)*meta_temp + 0.000147559*V(VPWR)*meta_vsup_max + 7.39465e-05*V(VREF)*V(VREF) + -0.0001427*V(VREF)*V(FUN_DC) + -0.0001427*V(VREF)*V(V_SUPPLY) + -0.0001427*V(VREF)*V(MOST_POS) + 0.000528189*V(VREF)*V(EN_LDO) + -0.00164373*V(VREF)*meta_corner + 8.70336e-07*V(VREF)*meta_temp + -0.0001427*V(VREF)*meta_vsup_max + 0.000147559*V(FUN_DC)*V(FUN_DC) + 0.000147559*V(FUN_DC)*V(V_SUPPLY) + 0.000147559*V(FUN_DC)*V(MOST_POS) + -0.00101929*V(FUN_DC)*V(EN_LDO) + 0.000431934*V(FUN_DC)*meta_corner + 9.86514e-07*V(FUN_DC)*meta_temp + 0.000147559*V(FUN_DC)*meta_vsup_max + 0.000147559*V(V_SUPPLY)*V(V_SUPPLY) + 0.000147559*V(V_SUPPLY)*V(MOST_POS) + -0.00101929*V(V_SUPPLY)*V(EN_LDO) + 0.000431934*V(V_SUPPLY)*meta_corner + 9.86466e-07*V(V_SUPPLY)*meta_temp + 0.000147559*V(V_SUPPLY)*meta_vsup_max + 0.000147559*V(MOST_POS)*V(MOST_POS) + -0.00101929*V(MOST_POS)*V(EN_LDO) + 0.000431934*V(MOST_POS)*meta_corner + 9.88938e-07*V(MOST_POS)*meta_temp + 0.000147559*V(MOST_POS)*meta_vsup_max + 0.00377278*V(EN_LDO)*V(EN_LDO) + -0.0117409*V(EN_LDO)*meta_corner + 6.27068e-06*V(EN_LDO)*meta_temp + -0.00101929*V(EN_LDO)*meta_vsup_max + -0.157419*meta_corner*meta_corner + -0.000163363*meta_corner*meta_temp + 0.000431934*meta_corner*meta_vsup_max + 8.81971e-08*meta_temp*meta_temp + 9.85843e-07*meta_temp*meta_vsup_max + 0.000147559*meta_vsup_max*meta_vsup_max + -0.207867*ddt(V(VPWR)) + 9.60269*ddt(V(VREF)) + -0.207867*ddt(V(FUN_DC)) + -0.207867*ddt(V(V_SUPPLY)) + -0.207867*ddt(V(MOST_POS)) + -1.77483*ddt(V(EN_LDO)) + 0.111308*idt(V(VPWR)) + -0.0585344*idt(V(VREF)) + 0.111308*idt(V(FUN_DC)) + 0.111308*idt(V(V_SUPPLY)) + 0.111308*idt(V(MOST_POS)) + -0.418105*idt(V(EN_LDO)) + 0.000150911;  // VPWR_I
                I(V_SUPPLY, GND) <+ -1.90234e-08*V(VPWR) + 6.49278e-09*V(VREF) + -1.90235e-08*V(FUN_DC) + -1.90234e-08*V(V_SUPPLY) + -1.90234e-08*V(MOST_POS) + 4.63808e-08*V(EN_LDO) + -4.68013e-08*meta_corner + -3.64412e-10*meta_temp + -1.90234e-08*meta_vsup_max + 1.7216e-08*V(VPWR)*V(VPWR) + -1.33164e-08*V(VPWR)*V(VREF) + 1.7216e-08*V(VPWR)*V(FUN_DC) + 1.7216e-08*V(VPWR)*V(V_SUPPLY) + 1.7216e-08*V(VPWR)*V(MOST_POS) + -9.51171e-08*V(VPWR)*V(EN_LDO) + 3.25919e-08*V(VPWR)*meta_corner + 4.03469e-10*V(VPWR)*meta_temp + 1.7216e-08*V(VPWR)*meta_vsup_max + 4.54532e-09*V(VREF)*V(VREF) + -1.33164e-08*V(VREF)*V(FUN_DC) + -1.33164e-08*V(VREF)*V(V_SUPPLY) + -1.33164e-08*V(VREF)*V(MOST_POS) + 3.24666e-08*V(VREF)*V(EN_LDO) + -3.27609e-08*V(VREF)*meta_corner + -2.55186e-10*V(VREF)*meta_temp + -1.33164e-08*V(VREF)*meta_vsup_max + 1.7216e-08*V(FUN_DC)*V(FUN_DC) + 1.7216e-08*V(FUN_DC)*V(V_SUPPLY) + 1.7216e-08*V(FUN_DC)*V(MOST_POS) + -9.51171e-08*V(FUN_DC)*V(EN_LDO) + 3.25919e-08*V(FUN_DC)*meta_corner + 4.03473e-10*V(FUN_DC)*meta_temp + 1.7216e-08*V(FUN_DC)*meta_vsup_max + 1.7216e-08*V(V_SUPPLY)*V(V_SUPPLY) + 1.7216e-08*V(V_SUPPLY)*V(MOST_POS) + -9.51171e-08*V(V_SUPPLY)*V(EN_LDO) + 3.25919e-08*V(V_SUPPLY)*meta_corner + 4.03471e-10*V(V_SUPPLY)*meta_temp + 1.7216e-08*V(V_SUPPLY)*meta_vsup_max + 1.7216e-08*V(MOST_POS)*V(MOST_POS) + -9.51171e-08*V(MOST_POS)*V(EN_LDO) + 3.25919e-08*V(MOST_POS)*meta_corner + 4.03494e-10*V(MOST_POS)*meta_temp + 1.7216e-08*V(MOST_POS)*meta_vsup_max + 2.31904e-07*V(EN_LDO)*V(EN_LDO) + -2.34007e-07*V(EN_LDO)*meta_corner + -1.82235e-09*V(EN_LDO)*meta_temp + -9.51171e-08*V(EN_LDO)*meta_vsup_max + -1.64515e-06*meta_corner*meta_corner + 6.84071e-10*meta_corner*meta_temp + 3.25919e-08*meta_corner*meta_vsup_max + 4.03465e-10*meta_temp*meta_vsup_max + 1.7216e-08*meta_vsup_max*meta_vsup_max + -3.72363e-05*ddt(V(VPWR)) + 8.93065e-05*ddt(V(VREF)) + -3.72363e-05*ddt(V(FUN_DC)) + -3.72363e-05*ddt(V(V_SUPPLY)) + -3.72363e-05*ddt(V(MOST_POS)) + 2.50535e-05*ddt(V(EN_LDO)) + 2.91419e-07*idt(V(VPWR)) + -1.71264e-07*idt(V(VREF)) + 2.91419e-07*idt(V(FUN_DC)) + 2.91419e-07*idt(V(V_SUPPLY)) + 2.91419e-07*idt(V(MOST_POS)) + -1.22334e-06*idt(V(EN_LDO)) + 9.27616e-09;  // V_SUPPLY_I
            end
            REGULATION_10: begin
                I(FUN_DC, GND) <+ 1.19104e-07*V(VPWR) + -3.25176e-08*V(VREF) + 1.18809e-07*V(FUN_DC) + 1.19088e-07*V(V_SUPPLY) + 1.19093e-07*V(MOST_POS) + -2.50472e-07*V(EN_LDO) + 2.198e-06*meta_corner + -5.9545e-09*meta_temp + 1.19091e-07*meta_vsup_max + -1.22339e-07*V(VPWR)*V(VPWR) + 8.33711e-08*V(VPWR)*V(VREF) + -1.22339e-07*V(VPWR)*V(FUN_DC) + -1.22339e-07*V(VPWR)*V(V_SUPPLY) + -1.22339e-07*V(VPWR)*V(MOST_POS) + 5.95511e-07*V(VPWR)*V(EN_LDO) + -2.18068e-06*V(VPWR)*meta_corner + 5.19806e-09*V(VPWR)*meta_temp + -1.22339e-07*V(VPWR)*meta_vsup_max + -2.45456e-08*V(VREF)*V(VREF) + 8.33711e-08*V(VREF)*V(FUN_DC) + 8.33711e-08*V(VREF)*V(V_SUPPLY) + 8.33711e-08*V(VREF)*V(MOST_POS) + -1.75333e-07*V(VREF)*V(EN_LDO) + 1.5386e-06*V(VREF)*meta_corner + -4.27985e-09*V(VREF)*meta_temp + 8.33711e-08*V(VREF)*meta_vsup_max + -1.22339e-07*V(FUN_DC)*V(FUN_DC) + -1.22339e-07*V(FUN_DC)*V(V_SUPPLY) + -1.22339e-07*V(FUN_DC)*V(MOST_POS) + 5.95511e-07*V(FUN_DC)*V(EN_LDO) + -2.18068e-06*V(FUN_DC)*meta_corner + 5.19406e-09*V(FUN_DC)*meta_temp + -1.22339e-07*V(FUN_DC)*meta_vsup_max + -1.22339e-07*V(V_SUPPLY)*V(V_SUPPLY) + -1.22339e-07*V(V_SUPPLY)*V(MOST_POS) + 5.95511e-07*V(V_SUPPLY)*V(EN_LDO) + -2.18068e-06*V(V_SUPPLY)*meta_corner + 5.19406e-09*V(V_SUPPLY)*meta_temp + -1.22339e-07*V(V_SUPPLY)*meta_vsup_max + -1.22339e-07*V(MOST_POS)*V(MOST_POS) + 5.95511e-07*V(MOST_POS)*V(EN_LDO) + -2.18068e-06*V(MOST_POS)*meta_corner + 5.19406e-09*V(MOST_POS)*meta_temp + -1.22339e-07*V(MOST_POS)*meta_vsup_max + -1.25238e-06*V(EN_LDO)*V(EN_LDO) + 1.099e-05*V(EN_LDO)*meta_corner + -2.82558e-08*V(EN_LDO)*meta_temp + 5.95511e-07*V(EN_LDO)*meta_vsup_max + 4.50306e-06*meta_corner*meta_corner + -4.49308e-08*meta_corner*meta_temp + -2.18068e-06*meta_corner*meta_vsup_max + 2.21501e-10*meta_temp*meta_temp + 5.19406e-09*meta_temp*meta_vsup_max + -1.22339e-07*meta_vsup_max*meta_vsup_max + -0.00546019*ddt(V(VPWR)) + 0.256747*ddt(V(VREF)) + -0.00546019*ddt(V(FUN_DC)) + -0.00546019*ddt(V(V_SUPPLY)) + -0.00546019*ddt(V(MOST_POS)) + 0.0410955*ddt(V(EN_LDO)) + 1.41727e-06*idt(V(VPWR)) + 9.65427e-08*idt(V(VREF)) + 1.41727e-06*idt(V(FUN_DC)) + 1.41727e-06*idt(V(V_SUPPLY)) + 1.41727e-06*idt(V(MOST_POS)) + -3.34628e-06*idt(V(EN_LDO)) + -5.00959e-08;  // FUN_DC_I
                I(MOST_POS, GND) <+ 5.76228e-07*V(VPWR) + -2.05497e-07*V(VREF) + 4.99476e-07*V(FUN_DC) + 5.71823e-07*V(V_SUPPLY) + 5.73062e-07*V(MOST_POS) + -6.09082e-06*V(EN_LDO) + -2.4843e-05*meta_corner + -2.84214e-08*meta_temp + 5.72464e-07*meta_vsup_max + 5.99117e-07*V(VPWR)*V(VPWR) + 4.02961e-07*V(VPWR)*V(VREF) + 5.99118e-07*V(VPWR)*V(FUN_DC) + 5.99118e-07*V(VPWR)*V(V_SUPPLY) + 5.99118e-07*V(VPWR)*V(MOST_POS) + 2.87904e-06*V(VPWR)*V(EN_LDO) + 1.2976e-05*V(VPWR)*meta_corner + -7.00879e-08*V(VPWR)*meta_temp + 5.99118e-07*V(VPWR)*meta_vsup_max + -5.96714e-07*V(VREF)*V(VREF) + 4.02961e-07*V(VREF)*V(FUN_DC) + 4.02961e-07*V(VREF)*V(V_SUPPLY) + 4.02961e-07*V(VREF)*V(MOST_POS) + -4.26436e-06*V(VREF)*V(EN_LDO) + -1.73908e-05*V(VREF)*meta_corner + -4.8205e-08*V(VREF)*meta_temp + 4.02961e-07*V(VREF)*meta_vsup_max + 5.99118e-07*V(FUN_DC)*V(FUN_DC) + 5.99118e-07*V(FUN_DC)*V(V_SUPPLY) + 5.99118e-07*V(FUN_DC)*V(MOST_POS) + 2.87904e-06*V(FUN_DC)*V(EN_LDO) + 1.2976e-05*V(FUN_DC)*meta_corner + -7.12874e-08*V(FUN_DC)*meta_temp + 5.99118e-07*V(FUN_DC)*meta_vsup_max + 5.99118e-07*V(V_SUPPLY)*V(V_SUPPLY) + 5.99118e-07*V(V_SUPPLY)*V(MOST_POS) + 2.87904e-06*V(V_SUPPLY)*V(EN_LDO) + 1.2976e-05*V(V_SUPPLY)*meta_corner + -7.12874e-08*V(V_SUPPLY)*meta_temp + 5.99118e-07*V(V_SUPPLY)*meta_vsup_max + 5.99118e-07*V(MOST_POS)*V(MOST_POS) + 2.87904e-06*V(MOST_POS)*V(EN_LDO) + 1.2976e-05*V(MOST_POS)*meta_corner + -7.12874e-08*V(MOST_POS)*meta_temp + 5.99118e-07*V(MOST_POS)*meta_vsup_max + -3.04595e-05*V(EN_LDO)*V(EN_LDO) + -0.000124219*V(EN_LDO)*meta_corner + 2.71498e-07*V(EN_LDO)*meta_temp + 2.87904e-06*V(EN_LDO)*meta_vsup_max + -0.00186853*meta_corner*meta_corner + -1.13464e-07*meta_corner*meta_temp + 1.2976e-05*meta_corner*meta_vsup_max + -5.78511e-10*meta_temp*meta_temp + -7.12874e-08*meta_temp*meta_vsup_max + 5.99118e-07*meta_vsup_max*meta_vsup_max + 0.087884*ddt(V(VPWR)) + 67.439*ddt(V(VREF)) + 0.087884*ddt(V(FUN_DC)) + 0.087884*ddt(V(V_SUPPLY)) + 0.087884*ddt(V(MOST_POS)) + -11.6432*ddt(V(EN_LDO)) + -0.000183163*idt(V(VPWR)) + 0.000979016*idt(V(VREF)) + -0.000183163*idt(V(FUN_DC)) + -0.000183163*idt(V(V_SUPPLY)) + -0.000183163*idt(V(MOST_POS)) + 0.00591562*idt(V(EN_LDO)) + -1.21853e-06;  // MOST_POS_I
                V(VDD_1V2) <+ 0.00214207*V(VPWR) + -0.00276188*V(VREF) + 0.0021718*V(FUN_DC) + 0.00214375*V(V_SUPPLY) + 0.00214325*V(MOST_POS) + -0.0179175*V(EN_LDO) + 0.23642*meta_corner + 0.000611937*meta_temp + 0.00214348*meta_vsup_max + 0.000627727*V(VPWR)*V(VPWR) + 0.00149962*V(VPWR)*V(VREF) + 0.000627727*V(VPWR)*V(FUN_DC) + 0.000627726*V(VPWR)*V(V_SUPPLY) + 0.000627726*V(VPWR)*V(MOST_POS) + 0.0107112*V(VPWR)*V(EN_LDO) + 0.127831*V(VPWR)*meta_corner + -0.000354501*V(VPWR)*meta_temp + 0.000627726*V(VPWR)*meta_vsup_max + -0.00175599*V(VREF)*V(VREF) + 0.00149962*V(VREF)*V(FUN_DC) + 0.00149962*V(VREF)*V(V_SUPPLY) + 0.00149962*V(VREF)*V(MOST_POS) + -0.012542*V(VREF)*V(EN_LDO) + 0.165495*V(VREF)*meta_corner + 0.000439436*V(VREF)*meta_temp + 0.00149962*V(VREF)*meta_vsup_max + 0.000627726*V(FUN_DC)*V(FUN_DC) + 0.000627726*V(FUN_DC)*V(V_SUPPLY) + 0.000627726*V(FUN_DC)*V(MOST_POS) + 0.0107112*V(FUN_DC)*V(EN_LDO) + 0.127831*V(FUN_DC)*meta_corner + -0.000354051*V(FUN_DC)*meta_temp + 0.000627726*V(FUN_DC)*meta_vsup_max + 0.000627726*V(V_SUPPLY)*V(V_SUPPLY) + 0.000627726*V(V_SUPPLY)*V(MOST_POS) + 0.0107112*V(V_SUPPLY)*V(EN_LDO) + 0.127831*V(V_SUPPLY)*meta_corner + -0.000354051*V(V_SUPPLY)*meta_temp + 0.000627726*V(V_SUPPLY)*meta_vsup_max + 0.000627726*V(MOST_POS)*V(MOST_POS) + 0.0107112*V(MOST_POS)*V(EN_LDO) + 0.127831*V(MOST_POS)*meta_corner + -0.000354051*V(MOST_POS)*meta_temp + 0.000627726*V(MOST_POS)*meta_vsup_max + -0.0895855*V(EN_LDO)*V(EN_LDO) + 1.1821*V(EN_LDO)*meta_corner + 0.00290255*V(EN_LDO)*meta_temp + 0.0107112*V(EN_LDO)*meta_vsup_max + 19.8997*meta_corner*meta_corner + 0.0106743*meta_corner*meta_temp + 0.127831*meta_corner*meta_vsup_max + -2.95115e-05*meta_temp*meta_temp + -0.000354051*meta_temp*meta_vsup_max + 0.000627726*meta_vsup_max*meta_vsup_max + 601.711*ddt(V(VPWR)) + -26040*ddt(V(VREF)) + 601.711*ddt(V(FUN_DC)) + 601.711*ddt(V(V_SUPPLY)) + 601.711*ddt(V(MOST_POS)) + 1530.06*ddt(V(EN_LDO)) + -1.36635*idt(V(VPWR)) + 0.7053*idt(V(VREF)) + -1.36635*idt(V(FUN_DC)) + -1.36635*idt(V(V_SUPPLY)) + -1.36635*idt(V(MOST_POS)) + 5.45125*idt(V(EN_LDO)) + -0.00358336;
                I(VPWR, GND) <+ -3.9917e-05*V(VPWR) + 3.61725e-05*V(VREF) + -4.02033e-05*V(FUN_DC) + -3.99321e-05*V(V_SUPPLY) + -3.99265e-05*V(MOST_POS) + 0.000240149*V(EN_LDO) + -0.00167235*meta_corner + -4.44285e-07*meta_temp + -3.99287e-05*meta_vsup_max + 4.06247e-05*V(VPWR)*V(VPWR) + -2.7944e-05*V(VPWR)*V(VREF) + 4.06247e-05*V(VPWR)*V(FUN_DC) + 4.06247e-05*V(VPWR)*V(V_SUPPLY) + 4.06247e-05*V(VPWR)*V(MOST_POS) + -0.000199597*V(VPWR)*V(EN_LDO) + -0.000464995*V(VPWR)*meta_corner + 3.1013e-06*V(VPWR)*meta_temp + 4.06247e-05*V(VPWR)*meta_vsup_max + 2.35351e-05*V(VREF)*V(VREF) + -2.7944e-05*V(VREF)*V(FUN_DC) + -2.7944e-05*V(VREF)*V(V_SUPPLY) + -2.7944e-05*V(VREF)*V(MOST_POS) + 0.000168101*V(VREF)*V(EN_LDO) + -0.00117065*V(VREF)*meta_corner + -4.22381e-07*V(VREF)*meta_temp + -2.7944e-05*V(VREF)*meta_vsup_max + 4.06247e-05*V(FUN_DC)*V(FUN_DC) + 4.06247e-05*V(FUN_DC)*V(V_SUPPLY) + 4.06247e-05*V(FUN_DC)*V(MOST_POS) + -0.000199597*V(FUN_DC)*V(EN_LDO) + -0.000464995*V(FUN_DC)*meta_corner + 3.09756e-06*V(FUN_DC)*meta_temp + 4.06247e-05*V(FUN_DC)*meta_vsup_max + 4.06247e-05*V(V_SUPPLY)*V(V_SUPPLY) + 4.06247e-05*V(V_SUPPLY)*V(MOST_POS) + -0.000199597*V(V_SUPPLY)*V(EN_LDO) + -0.000464995*V(V_SUPPLY)*meta_corner + 3.09756e-06*V(V_SUPPLY)*meta_temp + 4.06247e-05*V(V_SUPPLY)*meta_vsup_max + 4.06247e-05*V(MOST_POS)*V(MOST_POS) + -0.000199597*V(MOST_POS)*V(EN_LDO) + -0.000464995*V(MOST_POS)*meta_corner + 3.09756e-06*V(MOST_POS)*meta_temp + 4.06247e-05*V(MOST_POS)*meta_vsup_max + 0.00120072*V(EN_LDO)*V(EN_LDO) + -0.00836176*V(EN_LDO)*meta_corner + -8.29357e-07*V(EN_LDO)*meta_temp + -0.000199597*V(EN_LDO)*meta_vsup_max + -0.163684*meta_corner*meta_corner + -0.000141057*meta_corner*meta_temp + -0.000464995*meta_corner*meta_vsup_max + 1.00524e-08*meta_temp*meta_temp + 3.09756e-06*meta_temp*meta_vsup_max + 4.06247e-05*meta_vsup_max*meta_vsup_max + -30.8478*ddt(V(VPWR)) + 247.719*ddt(V(VREF)) + -30.8478*ddt(V(FUN_DC)) + -30.8478*ddt(V(V_SUPPLY)) + -30.8478*ddt(V(MOST_POS)) + 104.457*ddt(V(EN_LDO)) + 0.013926*idt(V(VPWR)) + -0.00518763*idt(V(VREF)) + 0.013926*idt(V(FUN_DC)) + 0.013926*idt(V(V_SUPPLY)) + 0.013926*idt(V(MOST_POS)) + -0.040883*idt(V(EN_LDO)) + 4.80282e-05;  // VPWR_I
                I(V_SUPPLY, GND) <+ -2.88817e-08*V(VPWR) + 1.00851e-08*V(VREF) + -2.88972e-08*V(FUN_DC) + -2.88826e-08*V(V_SUPPLY) + -2.88823e-08*V(MOST_POS) + 7.10645e-08*V(EN_LDO) + -6.33167e-08*meta_corner + -5.05759e-10*meta_temp + -2.88824e-08*meta_vsup_max + 2.58335e-08*V(VPWR)*V(VPWR) + -2.02173e-08*V(VPWR)*V(VREF) + 2.58335e-08*V(VPWR)*V(FUN_DC) + 2.58335e-08*V(VPWR)*V(V_SUPPLY) + 2.58335e-08*V(VPWR)*V(MOST_POS) + -1.44409e-07*V(VPWR)*V(EN_LDO) + 4.04566e-08*V(VPWR)*meta_corner + 5.47779e-10*V(VPWR)*meta_temp + 2.58335e-08*V(VPWR)*meta_vsup_max + 6.96435e-09*V(VREF)*V(VREF) + -2.02173e-08*V(VREF)*V(FUN_DC) + -2.02173e-08*V(VREF)*V(V_SUPPLY) + -2.02173e-08*V(VREF)*V(MOST_POS) + 4.97449e-08*V(VREF)*V(EN_LDO) + -4.43219e-08*V(VREF)*meta_corner + -3.59986e-10*V(VREF)*meta_temp + -2.02173e-08*V(VREF)*meta_vsup_max + 2.58335e-08*V(FUN_DC)*V(FUN_DC) + 2.58335e-08*V(FUN_DC)*V(V_SUPPLY) + 2.58335e-08*V(FUN_DC)*V(MOST_POS) + -1.44409e-07*V(FUN_DC)*V(EN_LDO) + 4.04566e-08*V(FUN_DC)*meta_corner + 5.47574e-10*V(FUN_DC)*meta_temp + 2.58335e-08*V(FUN_DC)*meta_vsup_max + 2.58335e-08*V(V_SUPPLY)*V(V_SUPPLY) + 2.58335e-08*V(V_SUPPLY)*V(MOST_POS) + -1.44409e-07*V(V_SUPPLY)*V(EN_LDO) + 4.04566e-08*V(V_SUPPLY)*meta_corner + 5.47574e-10*V(V_SUPPLY)*meta_temp + 2.58335e-08*V(V_SUPPLY)*meta_vsup_max + 2.58335e-08*V(MOST_POS)*V(MOST_POS) + -1.44409e-07*V(MOST_POS)*V(EN_LDO) + 4.04566e-08*V(MOST_POS)*meta_corner + 5.47574e-10*V(MOST_POS)*meta_temp + 2.58335e-08*V(MOST_POS)*meta_vsup_max + 3.55321e-07*V(EN_LDO)*V(EN_LDO) + -3.16585e-07*V(EN_LDO)*meta_corner + -2.45128e-09*V(EN_LDO)*meta_temp + -1.44409e-07*V(EN_LDO)*meta_vsup_max + -2.47159e-06*meta_corner*meta_corner + 1.19138e-09*meta_corner*meta_temp + 4.04566e-08*meta_corner*meta_vsup_max + 5.47574e-10*meta_temp*meta_vsup_max + 2.58335e-08*meta_vsup_max*meta_vsup_max + -0.000923234*ddt(V(VPWR)) + 0.0134518*ddt(V(VREF)) + -0.000923234*ddt(V(FUN_DC)) + -0.000923234*ddt(V(V_SUPPLY)) + -0.000923234*ddt(V(MOST_POS)) + 0.00406381*ddt(V(EN_LDO)) + 9.38267e-07*idt(V(VPWR)) + -4.66201e-07*idt(V(VREF)) + 9.38267e-07*idt(V(FUN_DC)) + 9.38267e-07*idt(V(V_SUPPLY)) + 9.38267e-07*idt(V(MOST_POS)) + -3.53962e-06*idt(V(EN_LDO)) + 1.42128e-08;  // V_SUPPLY_I
            end
            REGULATION_11: begin
                I(FUN_DC, GND) <+ -5.79348e-05*V(VPWR) + -8.53314e-05*V(VREF) + -5.79287e-05*V(FUN_DC) + -5.79345e-05*V(V_SUPPLY) + -5.79347e-05*V(MOST_POS) + -0.000608994*V(EN_LDO) + -0.00113664*meta_corner + 1.09696e-06*meta_temp + -5.79347e-05*meta_vsup_max + 2.1991e-05*V(VPWR)*V(VPWR) + -4.05543e-05*V(VPWR)*V(VREF) + 2.19911e-05*V(VPWR)*V(FUN_DC) + 2.19911e-05*V(VPWR)*V(V_SUPPLY) + 2.19911e-05*V(VPWR)*V(MOST_POS) + -0.000289674*V(VPWR)*V(EN_LDO) + 0.000142053*V(VPWR)*meta_corner + -1.82641e-07*V(VPWR)*meta_temp + 2.19911e-05*V(VPWR)*meta_vsup_max + -5.96814e-05*V(VREF)*V(VREF) + -4.05543e-05*V(VREF)*V(FUN_DC) + -4.05543e-05*V(VREF)*V(V_SUPPLY) + -4.05543e-05*V(VREF)*V(MOST_POS) + -0.000426296*V(VREF)*V(EN_LDO) + -0.000795648*V(VREF)*meta_corner + 7.88382e-07*V(VREF)*meta_temp + -4.05543e-05*V(VREF)*meta_vsup_max + 2.19911e-05*V(FUN_DC)*V(FUN_DC) + 2.19911e-05*V(FUN_DC)*V(V_SUPPLY) + 2.19911e-05*V(FUN_DC)*V(MOST_POS) + -0.000289674*V(FUN_DC)*V(EN_LDO) + 0.000142053*V(FUN_DC)*meta_corner + -1.83229e-07*V(FUN_DC)*meta_temp + 2.19911e-05*V(FUN_DC)*meta_vsup_max + 2.19911e-05*V(V_SUPPLY)*V(V_SUPPLY) + 2.19911e-05*V(V_SUPPLY)*V(MOST_POS) + -0.000289674*V(V_SUPPLY)*V(EN_LDO) + 0.000142053*V(V_SUPPLY)*meta_corner + -3.57365e-07*V(V_SUPPLY)*meta_temp + 2.19911e-05*V(V_SUPPLY)*meta_vsup_max + 2.19911e-05*V(MOST_POS)*V(MOST_POS) + -0.000289674*V(MOST_POS)*V(EN_LDO) + 0.000142053*V(MOST_POS)*meta_corner + -1.80138e-07*V(MOST_POS)*meta_temp + 2.19911e-05*V(MOST_POS)*meta_vsup_max + -0.00304497*V(EN_LDO)*V(EN_LDO) + -0.0056832*V(EN_LDO)*meta_corner + 5.45902e-06*V(EN_LDO)*meta_temp + -0.000289674*V(EN_LDO)*meta_vsup_max + -0.0835142*meta_corner*meta_corner + -6.7387e-05*meta_corner*meta_temp + 0.000142053*meta_corner*meta_vsup_max + 1.43425e-08*meta_temp*meta_temp + -1.80325e-07*meta_temp*meta_vsup_max + 2.19911e-05*meta_vsup_max*meta_vsup_max + -3.63445*ddt(V(VPWR)) + 54.0237*ddt(V(VREF)) + -3.63445*ddt(V(FUN_DC)) + -3.63445*ddt(V(V_SUPPLY)) + -3.63445*ddt(V(MOST_POS)) + 12.1711*ddt(V(EN_LDO)) + 0.0553439*idt(V(VPWR)) + 0.0877778*idt(V(VREF)) + 0.0553439*idt(V(FUN_DC)) + 0.0553439*idt(V(V_SUPPLY)) + 0.0553439*idt(V(MOST_POS)) + 0.627032*idt(V(EN_LDO)) + -0.000121799;  // FUN_DC_I
                I(MOST_POS, GND) <+ 0.000118785*V(VPWR) + -3.76115e-05*V(VREF) + 0.000118787*V(FUN_DC) + 0.000118785*V(V_SUPPLY) + 0.000118785*V(MOST_POS) + -0.000268467*V(EN_LDO) + -0.000421064*meta_corner + 1.01972e-06*meta_temp + 0.000118785*meta_vsup_max + 6.26873e-05*V(VPWR)*V(VPWR) + 8.31494e-05*V(VPWR)*V(VREF) + 6.26874e-05*V(VPWR)*V(FUN_DC) + 6.26874e-05*V(VPWR)*V(V_SUPPLY) + 6.26874e-05*V(VPWR)*V(MOST_POS) + 0.000593924*V(VPWR)*V(EN_LDO) + 0.000253814*V(VPWR)*meta_corner + -1.37762e-06*V(VPWR)*meta_temp + 6.26874e-05*V(VPWR)*meta_vsup_max + -2.63098e-05*V(VREF)*V(VREF) + 8.31494e-05*V(VREF)*V(FUN_DC) + 8.31494e-05*V(VREF)*V(V_SUPPLY) + 8.31494e-05*V(VREF)*V(MOST_POS) + -0.000187927*V(VREF)*V(EN_LDO) + -0.000294745*V(VREF)*meta_corner + 7.21193e-07*V(VREF)*meta_temp + 8.31494e-05*V(VREF)*meta_vsup_max + 6.26874e-05*V(FUN_DC)*V(FUN_DC) + 6.26874e-05*V(FUN_DC)*V(V_SUPPLY) + 6.26874e-05*V(FUN_DC)*V(MOST_POS) + 0.000593924*V(FUN_DC)*V(EN_LDO) + 0.000253814*V(FUN_DC)*meta_corner + -1.37783e-06*V(FUN_DC)*meta_temp + 6.26874e-05*V(FUN_DC)*meta_vsup_max + 6.26874e-05*V(V_SUPPLY)*V(V_SUPPLY) + 6.26874e-05*V(V_SUPPLY)*V(MOST_POS) + 0.000593924*V(V_SUPPLY)*V(EN_LDO) + 0.000253814*V(V_SUPPLY)*meta_corner + -1.44066e-06*V(V_SUPPLY)*meta_temp + 6.26874e-05*V(V_SUPPLY)*meta_vsup_max + 6.26874e-05*V(MOST_POS)*V(MOST_POS) + 0.000593924*V(MOST_POS)*V(EN_LDO) + 0.000253814*V(MOST_POS)*meta_corner + -1.37671e-06*V(MOST_POS)*meta_temp + 6.26874e-05*V(MOST_POS)*meta_vsup_max + -0.00134234*V(EN_LDO)*V(EN_LDO) + -0.00210532*V(EN_LDO)*meta_corner + 5.08918e-06*V(EN_LDO)*meta_temp + 0.000593924*V(EN_LDO)*meta_vsup_max + -0.0257313*meta_corner*meta_corner + -1.67165e-06*meta_corner*meta_temp + 0.000253814*meta_corner*meta_vsup_max + -1.43229e-08*meta_temp*meta_temp + -1.37679e-06*meta_temp*meta_vsup_max + 6.26874e-05*meta_vsup_max*meta_vsup_max + -1.06356*ddt(V(VPWR)) + 19.435*ddt(V(VREF)) + -1.06356*ddt(V(FUN_DC)) + -1.06356*ddt(V(V_SUPPLY)) + -1.06356*ddt(V(MOST_POS)) + 4.82016*ddt(V(EN_LDO)) + -0.197786*idt(V(VPWR)) + 0.0513131*idt(V(VREF)) + -0.197786*idt(V(FUN_DC)) + -0.197786*idt(V(V_SUPPLY)) + -0.197786*idt(V(MOST_POS)) + 0.366539*idt(V(EN_LDO)) + -5.36935e-05;  // MOST_POS_I
                V(VDD_1V2) <+ 0.000254129*V(VPWR) + -0.00226467*V(VREF) + 0.000254174*V(FUN_DC) + 0.000254131*V(V_SUPPLY) + 0.00025413*V(MOST_POS) + -0.0161725*V(EN_LDO) + 0.208621*meta_corner + 0.00068727*meta_temp + 0.00025413*meta_vsup_max + 0.00317958*V(VPWR)*V(VPWR) + 0.00017789*V(VPWR)*V(VREF) + 0.00317958*V(VPWR)*V(FUN_DC) + 0.00317958*V(VPWR)*V(V_SUPPLY) + 0.00317958*V(VPWR)*V(MOST_POS) + 0.00127064*V(VPWR)*V(EN_LDO) + 0.151093*V(VPWR)*meta_corner + -0.000436833*V(VPWR)*meta_temp + 0.00317958*V(VPWR)*meta_vsup_max + -0.00158491*V(VREF)*V(VREF) + 0.00017789*V(VREF)*V(FUN_DC) + 0.00017789*V(VREF)*V(V_SUPPLY) + 0.00017789*V(VREF)*V(MOST_POS) + -0.0113208*V(VREF)*V(EN_LDO) + 0.146035*V(VREF)*meta_corner + 0.000481237*V(VREF)*meta_temp + 0.00017789*V(VREF)*meta_vsup_max + 0.00317958*V(FUN_DC)*V(FUN_DC) + 0.00317958*V(FUN_DC)*V(V_SUPPLY) + 0.00317958*V(FUN_DC)*V(MOST_POS) + 0.00127064*V(FUN_DC)*V(EN_LDO) + 0.151093*V(FUN_DC)*meta_corner + -0.000436838*V(FUN_DC)*meta_temp + 0.00317958*V(FUN_DC)*meta_vsup_max + 0.00317958*V(V_SUPPLY)*V(V_SUPPLY) + 0.00317958*V(V_SUPPLY)*V(MOST_POS) + 0.00127064*V(V_SUPPLY)*V(EN_LDO) + 0.151093*V(V_SUPPLY)*meta_corner + -0.000438107*V(V_SUPPLY)*meta_temp + 0.00317958*V(V_SUPPLY)*meta_vsup_max + 0.00317958*V(MOST_POS)*V(MOST_POS) + 0.00127064*V(MOST_POS)*V(EN_LDO) + 0.151093*V(MOST_POS)*meta_corner + -0.000436815*V(MOST_POS)*meta_temp + 0.00317958*V(MOST_POS)*meta_vsup_max + -0.0808626*V(EN_LDO)*V(EN_LDO) + 1.0431*V(EN_LDO)*meta_corner + 0.00343615*V(EN_LDO)*meta_temp + 0.00127064*V(EN_LDO)*meta_vsup_max + 19.7004*meta_corner*meta_corner + 0.0117209*meta_corner*meta_temp + 0.151093*meta_corner*meta_vsup_max + -3.36252e-05*meta_temp*meta_temp + -0.000436818*meta_temp*meta_vsup_max + 0.00317958*meta_vsup_max*meta_vsup_max + 48.971*ddt(V(VPWR)) + 394.933*ddt(V(VREF)) + 48.971*ddt(V(FUN_DC)) + 48.971*ddt(V(V_SUPPLY)) + 48.971*ddt(V(MOST_POS)) + 144.654*ddt(V(EN_LDO)) + -1.64794*idt(V(VPWR)) + 0.948482*idt(V(VREF)) + -1.64794*idt(V(FUN_DC)) + -1.64794*idt(V(V_SUPPLY)) + -1.64794*idt(V(MOST_POS)) + 6.7752*idt(V(EN_LDO)) + -0.00323451;
                I(VPWR, GND) <+ -2.72729e-05*V(VPWR) + 5.44299e-05*V(VREF) + -2.72767e-05*V(FUN_DC) + -2.7273e-05*V(V_SUPPLY) + -2.72729e-05*V(MOST_POS) + 0.00038846*V(EN_LDO) + -3.20917e-05*meta_corner + -1.23779e-06*meta_temp + -2.72729e-05*meta_vsup_max + -2.41765e-05*V(VPWR)*V(VPWR) + -1.9091e-05*V(VPWR)*V(VREF) + -2.41765e-05*V(VPWR)*V(FUN_DC) + -2.41765e-05*V(VPWR)*V(V_SUPPLY) + -2.41765e-05*V(VPWR)*V(MOST_POS) + -0.000136364*V(VPWR)*V(EN_LDO) + -0.000411834*V(VPWR)*meta_corner + 2.20081e-06*V(VPWR)*meta_temp + -2.41765e-05*V(VPWR)*meta_vsup_max + 3.8069e-05*V(VREF)*V(VREF) + -1.9091e-05*V(VREF)*V(FUN_DC) + -1.9091e-05*V(VREF)*V(V_SUPPLY) + -1.9091e-05*V(VREF)*V(MOST_POS) + 0.000271922*V(VREF)*V(EN_LDO) + -2.24642e-05*V(VREF)*meta_corner + -8.79502e-07*V(VREF)*meta_temp + -1.9091e-05*V(VREF)*meta_vsup_max + -2.41765e-05*V(FUN_DC)*V(FUN_DC) + -2.41765e-05*V(FUN_DC)*V(V_SUPPLY) + -2.41765e-05*V(FUN_DC)*V(MOST_POS) + -0.000136364*V(FUN_DC)*V(EN_LDO) + -0.000411834*V(FUN_DC)*meta_corner + 2.20117e-06*V(FUN_DC)*meta_temp + -2.41765e-05*V(FUN_DC)*meta_vsup_max + -2.41765e-05*V(V_SUPPLY)*V(V_SUPPLY) + -2.41765e-05*V(V_SUPPLY)*V(MOST_POS) + -0.000136364*V(V_SUPPLY)*V(EN_LDO) + -0.000411834*V(V_SUPPLY)*meta_corner + 2.31396e-06*V(V_SUPPLY)*meta_temp + -2.41765e-05*V(V_SUPPLY)*meta_vsup_max + -2.41765e-05*V(MOST_POS)*V(MOST_POS) + -0.000136364*V(MOST_POS)*V(EN_LDO) + -0.000411834*V(MOST_POS)*meta_corner + 2.19923e-06*V(MOST_POS)*meta_temp + -2.41765e-05*V(MOST_POS)*meta_vsup_max + 0.0019423*V(EN_LDO)*V(EN_LDO) + -0.000160459*V(EN_LDO)*meta_corner + -6.16984e-06*V(EN_LDO)*meta_temp + -0.000136364*V(EN_LDO)*meta_vsup_max + -0.0247513*meta_corner*meta_corner + -3.06785e-05*meta_corner*meta_temp + -0.000411834*meta_corner*meta_vsup_max + 1.00832e-08*meta_temp*meta_temp + 2.19939e-06*meta_temp*meta_vsup_max + -2.41765e-05*meta_vsup_max*meta_vsup_max + 1.8204*ddt(V(VPWR)) + -33.5316*ddt(V(VREF)) + 1.8204*ddt(V(FUN_DC)) + 1.8204*ddt(V(V_SUPPLY)) + 1.8204*ddt(V(MOST_POS)) + -13.8372*ddt(V(EN_LDO)) + 0.0530869*idt(V(VPWR)) + -0.0514483*idt(V(VREF)) + 0.0530869*idt(V(FUN_DC)) + 0.0530869*idt(V(V_SUPPLY)) + 0.0530869*idt(V(MOST_POS)) + -0.367518*idt(V(EN_LDO)) + 7.76919e-05;  // VPWR_I
                I(V_SUPPLY, GND) <+ 3.3094e-06*V(VPWR) + -1.17953e-06*V(VREF) + 3.30941e-06*V(FUN_DC) + 3.3094e-06*V(V_SUPPLY) + 3.3094e-06*V(MOST_POS) + -8.42396e-06*V(EN_LDO) + -5.83113e-06*meta_corner + 4.06604e-09*meta_temp + 3.3094e-06*meta_vsup_max + 2.77671e-08*V(VPWR)*V(VPWR) + 2.31658e-06*V(VPWR)*V(VREF) + 2.77671e-08*V(VPWR)*V(FUN_DC) + 2.77671e-08*V(VPWR)*V(V_SUPPLY) + 2.77671e-08*V(VPWR)*V(MOST_POS) + 1.6547e-05*V(VPWR)*V(EN_LDO) + 2.02742e-06*V(VPWR)*meta_corner + -1.24403e-08*V(VPWR)*meta_temp + 2.77671e-08*V(VPWR)*meta_vsup_max + -8.25548e-07*V(VREF)*V(VREF) + 2.31658e-06*V(VREF)*V(FUN_DC) + 2.31658e-06*V(VREF)*V(V_SUPPLY) + 2.31658e-06*V(VREF)*V(MOST_POS) + -5.89677e-06*V(VREF)*V(EN_LDO) + -4.08179e-06*V(VREF)*meta_corner + 2.89358e-09*V(VREF)*meta_temp + 2.31658e-06*V(VREF)*meta_vsup_max + 2.77671e-08*V(FUN_DC)*V(FUN_DC) + 2.77671e-08*V(FUN_DC)*V(V_SUPPLY) + 2.77671e-08*V(FUN_DC)*V(MOST_POS) + 1.6547e-05*V(FUN_DC)*V(EN_LDO) + 2.02742e-06*V(FUN_DC)*meta_corner + -1.24421e-08*V(FUN_DC)*meta_temp + 2.77671e-08*V(FUN_DC)*meta_vsup_max + 2.77671e-08*V(V_SUPPLY)*V(V_SUPPLY) + 2.77671e-08*V(V_SUPPLY)*V(MOST_POS) + 1.6547e-05*V(V_SUPPLY)*V(EN_LDO) + 2.02742e-06*V(V_SUPPLY)*meta_corner + -1.28095e-08*V(V_SUPPLY)*meta_temp + 2.77671e-08*V(V_SUPPLY)*meta_vsup_max + 2.77671e-08*V(MOST_POS)*V(MOST_POS) + 1.6547e-05*V(MOST_POS)*V(EN_LDO) + 2.02742e-06*V(MOST_POS)*meta_corner + -1.24343e-08*V(MOST_POS)*meta_temp + 2.77671e-08*V(MOST_POS)*meta_vsup_max + -4.21198e-05*V(EN_LDO)*V(EN_LDO) + -2.91556e-05*V(EN_LDO)*meta_corner + 2.03177e-08*V(EN_LDO)*meta_temp + 1.6547e-05*V(EN_LDO)*meta_vsup_max + -0.000559629*meta_corner*meta_corner + -7.76535e-08*meta_corner*meta_temp + 2.02742e-06*meta_corner*meta_vsup_max + 1.45933e-10*meta_temp*meta_temp + -1.24344e-08*meta_temp*meta_vsup_max + 2.77671e-08*meta_vsup_max*meta_vsup_max + 0.0050116*ddt(V(VPWR)) + 0.140829*ddt(V(VREF)) + 0.0050116*ddt(V(FUN_DC)) + 0.0050116*ddt(V(V_SUPPLY)) + 0.0050116*ddt(V(MOST_POS)) + -0.0658654*ddt(V(EN_LDO)) + -0.0035259*idt(V(VPWR)) + 0.00100645*idt(V(VREF)) + -0.0035259*idt(V(FUN_DC)) + -0.0035259*idt(V(V_SUPPLY)) + -0.0035259*idt(V(MOST_POS)) + 0.00718904*idt(V(EN_LDO)) + -1.68479e-06;  // V_SUPPLY_I
            end
            REGULATION_12: begin
                I(FUN_DC, GND) <+ -6.07779e-05*V(VPWR) + 4.01841e-05*V(VREF) + -6.45286e-05*V(FUN_DC) + -6.58632e-05*V(V_SUPPLY) + -6.56323e-05*V(MOST_POS) + 0.000261459*V(EN_LDO) + -0.00175855*meta_corner + 7.92248e-06*meta_temp + -6.56904e-05*meta_vsup_max + 7.38828e-05*V(VPWR)*V(VPWR) + -4.49129e-05*V(VPWR)*V(VREF) + 7.38828e-05*V(VPWR)*V(FUN_DC) + 7.38828e-05*V(VPWR)*V(V_SUPPLY) + 7.38828e-05*V(VPWR)*V(MOST_POS) + -0.000302815*V(VPWR)*V(EN_LDO) + -0.000389268*V(VPWR)*meta_corner + 2.82209e-06*V(VPWR)*meta_temp + 7.38828e-05*V(VPWR)*meta_vsup_max + 2.59765e-05*V(VREF)*V(VREF) + -4.49128e-05*V(VREF)*V(FUN_DC) + -4.49128e-05*V(VREF)*V(V_SUPPLY) + -4.49128e-05*V(VREF)*V(MOST_POS) + 0.000184623*V(VREF)*V(EN_LDO) + -0.00123092*V(VREF)*meta_corner + -2.9525e-06*V(VREF)*meta_temp + -4.49128e-05*V(VREF)*meta_vsup_max + 7.38828e-05*V(FUN_DC)*V(FUN_DC) + 7.38828e-05*V(FUN_DC)*V(V_SUPPLY) + 7.38828e-05*V(FUN_DC)*V(MOST_POS) + -0.000302815*V(FUN_DC)*V(EN_LDO) + -0.000389267*V(FUN_DC)*meta_corner + 2.95056e-06*V(FUN_DC)*meta_temp + 7.38828e-05*V(FUN_DC)*meta_vsup_max + 7.38828e-05*V(V_SUPPLY)*V(V_SUPPLY) + 7.38828e-05*V(V_SUPPLY)*V(MOST_POS) + -0.000302815*V(V_SUPPLY)*V(EN_LDO) + -0.000389267*V(V_SUPPLY)*meta_corner + 2.95056e-06*V(V_SUPPLY)*meta_temp + 7.38828e-05*V(V_SUPPLY)*meta_vsup_max + 7.38828e-05*V(MOST_POS)*V(MOST_POS) + -0.000302815*V(MOST_POS)*V(EN_LDO) + -0.000389267*V(MOST_POS)*meta_corner + 2.95056e-06*V(MOST_POS)*meta_temp + 7.38828e-05*V(MOST_POS)*meta_vsup_max + 0.00132513*V(EN_LDO)*V(EN_LDO) + -0.00879214*V(EN_LDO)*meta_corner + -1.50897e-06*V(EN_LDO)*meta_temp + -0.000302815*V(EN_LDO)*meta_vsup_max + -0.166672*meta_corner*meta_corner + -0.000142774*meta_corner*meta_temp + -0.000389267*meta_corner*meta_vsup_max + 1.66143e-08*meta_temp*meta_temp + 2.95056e-06*meta_temp*meta_vsup_max + 7.38828e-05*meta_vsup_max*meta_vsup_max + -0.644521*ddt(V(VPWR)) + -38.5848*ddt(V(VREF)) + -0.644521*ddt(V(FUN_DC)) + -0.644521*ddt(V(V_SUPPLY)) + -0.644521*ddt(V(MOST_POS)) + -1.04127*ddt(V(EN_LDO)) + -0.00820272*idt(V(VPWR)) + 0.00419284*idt(V(VREF)) + -0.00820272*idt(V(FUN_DC)) + -0.00820272*idt(V(V_SUPPLY)) + -0.00820272*idt(V(MOST_POS)) + 0.0300707*idt(V(EN_LDO)) + 5.21796e-05;  // FUN_DC_I
                I(MOST_POS, GND) <+ -1.11125e-05*V(VPWR) + 4.59706e-06*V(VREF) + -1.05216e-05*V(FUN_DC) + -1.03113e-05*V(V_SUPPLY) + -1.03477e-05*V(MOST_POS) + 3.68631e-05*V(EN_LDO) + -2.77206e-05*meta_corner + -1.27256e-06*meta_temp + -1.03386e-05*meta_vsup_max + 7.31419e-07*V(VPWR)*V(VPWR) + -7.40564e-06*V(VPWR)*V(VREF) + 7.3142e-07*V(VPWR)*V(FUN_DC) + 7.3142e-07*V(VPWR)*V(V_SUPPLY) + 7.3142e-07*V(VPWR)*V(MOST_POS) + -5.57319e-05*V(VPWR)*V(EN_LDO) + 1.17838e-05*V(VPWR)*meta_corner + -1.08518e-08*V(VPWR)*meta_temp + 7.3142e-07*V(VPWR)*meta_vsup_max + 3.55688e-06*V(VREF)*V(VREF) + -7.40565e-06*V(VREF)*V(FUN_DC) + -7.40565e-06*V(VREF)*V(V_SUPPLY) + -7.40565e-06*V(VREF)*V(MOST_POS) + 2.55517e-05*V(VREF)*V(EN_LDO) + -1.94143e-05*V(VREF)*meta_corner + 4.48105e-07*V(VREF)*meta_temp + -7.40565e-06*V(VREF)*meta_vsup_max + 7.3142e-07*V(FUN_DC)*V(FUN_DC) + 7.3142e-07*V(FUN_DC)*V(V_SUPPLY) + 7.3142e-07*V(FUN_DC)*V(MOST_POS) + -5.57319e-05*V(FUN_DC)*V(EN_LDO) + 1.17836e-05*V(FUN_DC)*meta_corner + -3.10854e-08*V(FUN_DC)*meta_temp + 7.3142e-07*V(FUN_DC)*meta_vsup_max + 7.3142e-07*V(V_SUPPLY)*V(V_SUPPLY) + 7.3142e-07*V(V_SUPPLY)*V(MOST_POS) + -5.57319e-05*V(V_SUPPLY)*V(EN_LDO) + 1.17836e-05*V(V_SUPPLY)*meta_corner + -3.10854e-08*V(V_SUPPLY)*meta_temp + 7.3142e-07*V(V_SUPPLY)*meta_vsup_max + 7.3142e-07*V(MOST_POS)*V(MOST_POS) + -5.57319e-05*V(MOST_POS)*V(EN_LDO) + 1.17836e-05*V(MOST_POS)*meta_corner + -3.10854e-08*V(MOST_POS)*meta_temp + 7.3142e-07*V(MOST_POS)*meta_vsup_max + 0.000181506*V(EN_LDO)*V(EN_LDO) + -0.000138701*V(EN_LDO)*meta_corner + 1.15615e-07*V(EN_LDO)*meta_temp + -5.57319e-05*V(EN_LDO)*meta_vsup_max + -0.00231628*meta_corner*meta_corner + -4.75366e-07*meta_corner*meta_temp + 1.17836e-05*meta_corner*meta_vsup_max + 2.50528e-09*meta_temp*meta_temp + -3.10854e-08*meta_temp*meta_vsup_max + 7.3142e-07*meta_vsup_max*meta_vsup_max + -0.628073*ddt(V(VPWR)) + 6.00014*ddt(V(VREF)) + -0.628073*ddt(V(FUN_DC)) + -0.628073*ddt(V(V_SUPPLY)) + -0.628073*ddt(V(MOST_POS)) + -1.55594*ddt(V(EN_LDO)) + 0.0110897*idt(V(VPWR)) + -0.00395349*idt(V(VREF)) + 0.0110897*idt(V(FUN_DC)) + 0.0110897*idt(V(V_SUPPLY)) + 0.0110897*idt(V(MOST_POS)) + -0.0282585*idt(V(EN_LDO)) + 7.39029e-06;  // MOST_POS_I
                V(VDD_1V2) <+ -0.00113763*V(VPWR) + -0.00113582*V(VREF) + -0.00102852*V(FUN_DC) + -0.00098974*V(V_SUPPLY) + -0.000996455*V(MOST_POS) + -0.00736971*V(EN_LDO) + 0.23356*meta_corner + 0.000367842*meta_temp + -0.000994766*meta_vsup_max + 0.00257711*V(VPWR)*V(VPWR) + -0.000727466*V(VPWR)*V(VREF) + 0.00257711*V(VPWR)*V(FUN_DC) + 0.00257711*V(VPWR)*V(V_SUPPLY) + 0.00257711*V(VPWR)*V(MOST_POS) + -0.0057194*V(VPWR)*V(EN_LDO) + 0.128118*V(VPWR)*meta_corner + -0.000351311*V(VPWR)*meta_temp + 0.00257711*V(VPWR)*meta_vsup_max + -0.000732513*V(VREF)*V(VREF) + -0.000727467*V(VREF)*V(FUN_DC) + -0.000727467*V(VREF)*V(V_SUPPLY) + -0.000727467*V(VREF)*V(MOST_POS) + -0.00520539*V(VREF)*V(EN_LDO) + 0.16349*V(VREF)*meta_corner + 0.000504635*V(VREF)*meta_temp + -0.000727467*V(VREF)*meta_vsup_max + 0.00257711*V(FUN_DC)*V(FUN_DC) + 0.00257711*V(FUN_DC)*V(V_SUPPLY) + 0.00257711*V(FUN_DC)*V(MOST_POS) + -0.0057194*V(FUN_DC)*V(EN_LDO) + 0.128118*V(FUN_DC)*meta_corner + -0.000355052*V(FUN_DC)*meta_temp + 0.00257711*V(FUN_DC)*meta_vsup_max + 0.00257711*V(V_SUPPLY)*V(V_SUPPLY) + 0.00257711*V(V_SUPPLY)*V(MOST_POS) + -0.0057194*V(V_SUPPLY)*V(EN_LDO) + 0.128118*V(V_SUPPLY)*meta_corner + -0.000355052*V(V_SUPPLY)*meta_temp + 0.00257711*V(V_SUPPLY)*meta_vsup_max + 0.00257711*V(MOST_POS)*V(MOST_POS) + -0.0057194*V(MOST_POS)*V(EN_LDO) + 0.128118*V(MOST_POS)*meta_corner + -0.000355052*V(MOST_POS)*meta_temp + 0.00257711*V(MOST_POS)*meta_vsup_max + -0.0373671*V(EN_LDO)*V(EN_LDO) + 1.16778*V(EN_LDO)*meta_corner + 0.00303515*V(EN_LDO)*meta_temp + -0.0057194*V(EN_LDO)*meta_vsup_max + 19.8555*meta_corner*meta_corner + 0.0111756*meta_corner*meta_temp + 0.128118*meta_corner*meta_vsup_max + -3.21561e-05*meta_temp*meta_temp + -0.000355052*meta_temp*meta_vsup_max + 0.00257711*meta_vsup_max*meta_vsup_max + -168.503*ddt(V(VPWR)) + 1130.9*ddt(V(VREF)) + -168.503*ddt(V(FUN_DC)) + -168.503*ddt(V(V_SUPPLY)) + -168.503*ddt(V(MOST_POS)) + 650.519*ddt(V(EN_LDO)) + 0.281428*idt(V(VPWR)) + -0.117199*idt(V(VREF)) + 0.281428*idt(V(FUN_DC)) + 0.281428*idt(V(V_SUPPLY)) + 0.281428*idt(V(MOST_POS)) + -0.840641*idt(V(EN_LDO)) + -0.00147068;
                I(VPWR, GND) <+ 1.30624e-07*V(VPWR) + -7.69572e-08*V(VREF) + 1.24264e-07*V(FUN_DC) + 1.22003e-07*V(V_SUPPLY) + 1.22395e-07*V(MOST_POS) + -5.93024e-07*V(EN_LDO) + -1.96698e-06*meta_corner + 2.56462e-08*meta_temp + 1.22296e-07*meta_vsup_max + -4.19069e-08*V(VPWR)*V(VPWR) + 8.7422e-08*V(VPWR)*V(VREF) + -4.19069e-08*V(VPWR)*V(FUN_DC) + -4.19069e-08*V(VPWR)*V(V_SUPPLY) + -4.19069e-08*V(VPWR)*V(MOST_POS) + 6.54943e-07*V(VPWR)*V(EN_LDO) + 3.14096e-06*V(VPWR)*meta_corner + -1.81626e-08*V(VPWR)*meta_temp + -4.19069e-08*V(VPWR)*meta_vsup_max + -5.7517e-08*V(VREF)*V(VREF) + 8.74221e-08*V(VREF)*V(FUN_DC) + 8.74221e-08*V(VREF)*V(V_SUPPLY) + 8.74221e-08*V(VREF)*V(MOST_POS) + -4.12401e-07*V(VREF)*V(EN_LDO) + -1.37678e-06*V(VREF)*meta_corner + 3.54558e-09*V(VREF)*meta_temp + 8.74221e-08*V(VREF)*meta_vsup_max + -4.19069e-08*V(FUN_DC)*V(FUN_DC) + -4.19069e-08*V(FUN_DC)*V(V_SUPPLY) + -4.19069e-08*V(FUN_DC)*V(MOST_POS) + 6.54943e-07*V(FUN_DC)*V(EN_LDO) + 3.14096e-06*V(FUN_DC)*meta_corner + -1.79445e-08*V(FUN_DC)*meta_temp + -4.19069e-08*V(FUN_DC)*meta_vsup_max + -4.19069e-08*V(V_SUPPLY)*V(V_SUPPLY) + -4.19069e-08*V(V_SUPPLY)*V(MOST_POS) + 6.54943e-07*V(V_SUPPLY)*V(EN_LDO) + 3.14096e-06*V(V_SUPPLY)*meta_corner + -1.79445e-08*V(V_SUPPLY)*meta_temp + -4.19069e-08*V(V_SUPPLY)*meta_vsup_max + -4.19069e-08*V(MOST_POS)*V(MOST_POS) + 6.54943e-07*V(MOST_POS)*V(EN_LDO) + 3.14096e-06*V(MOST_POS)*meta_corner + -1.79445e-08*V(MOST_POS)*meta_temp + -4.19069e-08*V(MOST_POS)*meta_vsup_max + -2.93489e-06*V(EN_LDO)*V(EN_LDO) + -9.83383e-06*V(EN_LDO)*meta_corner + 5.85161e-08*V(EN_LDO)*meta_temp + 6.54943e-07*V(EN_LDO)*meta_vsup_max + 0.000102356*meta_corner*meta_corner + 7.51634e-08*meta_corner*meta_temp + 3.14096e-06*meta_corner*meta_vsup_max + 1.10611e-09*meta_temp*meta_temp + -1.79445e-08*meta_temp*meta_vsup_max + -4.19069e-08*meta_vsup_max*meta_vsup_max + 0.0084396*ddt(V(VPWR)) + -0.0660162*ddt(V(VREF)) + 0.0084396*ddt(V(FUN_DC)) + 0.0084396*ddt(V(V_SUPPLY)) + 0.0084396*ddt(V(MOST_POS)) + -0.039121*ddt(V(EN_LDO)) + -7.96342e-05*idt(V(VPWR)) + 4.46776e-05*idt(V(VREF)) + -7.96342e-05*idt(V(FUN_DC)) + -7.96342e-05*idt(V(V_SUPPLY)) + -7.96342e-05*idt(V(MOST_POS)) + 0.00031933*idt(V(EN_LDO)) + -1.18795e-07;  // VPWR_I
                I(V_SUPPLY, GND) <+ -1.9754e-08*V(VPWR) + 6.65556e-09*V(VREF) + -1.96426e-08*V(FUN_DC) + -1.9603e-08*V(V_SUPPLY) + -1.96099e-08*V(MOST_POS) + 4.82988e-08*V(EN_LDO) + -4.41115e-08*meta_corner + -6.13935e-10*meta_temp + -1.96081e-08*meta_vsup_max + 1.79049e-08*V(VPWR)*V(VPWR) + -1.37575e-08*V(VPWR)*V(VREF) + 1.79049e-08*V(VPWR)*V(FUN_DC) + 1.79049e-08*V(VPWR)*V(V_SUPPLY) + 1.79049e-08*V(VPWR)*V(MOST_POS) + -9.88018e-08*V(VPWR)*V(EN_LDO) + 2.83364e-08*V(VPWR)*meta_corner + 4.23406e-10*V(VPWR)*meta_temp + 1.79049e-08*V(VPWR)*meta_vsup_max + 4.72279e-09*V(VREF)*V(VREF) + -1.37575e-08*V(VREF)*V(FUN_DC) + -1.37575e-08*V(VREF)*V(V_SUPPLY) + -1.37575e-08*V(VREF)*V(MOST_POS) + 3.37616e-08*V(VREF)*V(EN_LDO) + -3.08799e-08*V(VREF)*meta_corner + -1.77432e-10*V(VREF)*meta_temp + -1.37575e-08*V(VREF)*meta_vsup_max + 1.79049e-08*V(FUN_DC)*V(FUN_DC) + 1.79049e-08*V(FUN_DC)*V(V_SUPPLY) + 1.79049e-08*V(FUN_DC)*V(MOST_POS) + -9.88018e-08*V(FUN_DC)*V(EN_LDO) + 2.83364e-08*V(FUN_DC)*meta_corner + 4.19591e-10*V(FUN_DC)*meta_temp + 1.79049e-08*V(FUN_DC)*meta_vsup_max + 1.79049e-08*V(V_SUPPLY)*V(V_SUPPLY) + 1.79049e-08*V(V_SUPPLY)*V(MOST_POS) + -9.88018e-08*V(V_SUPPLY)*V(EN_LDO) + 2.83364e-08*V(V_SUPPLY)*meta_corner + 4.19591e-10*V(V_SUPPLY)*meta_temp + 1.79049e-08*V(V_SUPPLY)*meta_vsup_max + 1.79049e-08*V(MOST_POS)*V(MOST_POS) + -9.88018e-08*V(MOST_POS)*V(EN_LDO) + 2.83364e-08*V(MOST_POS)*meta_corner + 4.19591e-10*V(MOST_POS)*meta_temp + 1.79049e-08*V(MOST_POS)*meta_vsup_max + 2.40965e-07*V(EN_LDO)*V(EN_LDO) + -2.20576e-07*V(EN_LDO)*meta_corner + -1.84874e-09*V(EN_LDO)*meta_temp + -9.88018e-08*V(EN_LDO)*meta_vsup_max + -1.72208e-06*meta_corner*meta_corner + 9.28554e-10*meta_corner*meta_temp + 2.83364e-08*meta_corner*meta_vsup_max + 4.19591e-10*meta_temp*meta_vsup_max + 1.79049e-08*meta_vsup_max*meta_vsup_max + -3.76322e-05*ddt(V(VPWR)) + 0.00114336*ddt(V(VREF)) + -3.76322e-05*ddt(V(FUN_DC)) + -3.76322e-05*ddt(V(V_SUPPLY)) + -3.76322e-05*ddt(V(MOST_POS)) + 3.85578e-05*ddt(V(EN_LDO)) + 6.67586e-08*idt(V(VPWR)) + -5.72556e-08*idt(V(VREF)) + 6.67586e-08*idt(V(FUN_DC)) + 6.67586e-08*idt(V(V_SUPPLY)) + 6.67586e-08*idt(V(MOST_POS)) + -4.12584e-07*idt(V(EN_LDO)) + 9.6631e-09;  // V_SUPPLY_I
            end
            default: ;
        endcase

        V(EN_UVLO_1V2) <+ ((current_state == REGULATION) || (current_state == REGULATION_2) || (current_state == REGULATION_3) || (current_state == REGULATION_4) || (current_state == REGULATION_5) || (current_state == REGULATION_6) || (current_state == REGULATION_7) || (current_state == REGULATION_8) || (current_state == REGULATION_9) || (current_state == REGULATION_10) || (current_state == REGULATION_11) || (current_state == REGULATION_12)) ? 5.5 : 0.0;

    end  // analog begin

endmodule

// Auto-generated Verilog-A FSM — LDO
// Generated by surrogate_framework FSMCodeGenerator

`include "disciplines.vams"
`include "constants.vams"

module ldo_fsm_model(
    VPWR, GND, floop_out, floop_in, EN_LDO, EN_UVLO_1V2, VPWR_SEL, PAD_VDD1V2_SEL, UVLO_GD_OR_OVERRIDE_MPOS, HIGH_POWER_MODE, SCAN_MODE_VSUPPLY, EN_SCAN_MODE_MPOS, FS_V_SUPPLY_TO_MOST_POS, SREF_ADD_LDO1V2_LOAD_MPOS, SREF_EN_ISENSE_LDO1V2_MPOS, SREF_LDO_ISNS_DIS_MPOS, IBIAS_SNK_25nA_0, IBIAS_SNK_25nA_1, IBIAS_SNK_25nA_2, ICONST_75A, VFB, VREF, AVSS, PBKG, FUN_DC, ISO, MOST_POS, VDD_1V2, VDD_1V2_EXT, V_SUPPLY
);

    input floop_in, IBIAS_SNK_25nA_0, IBIAS_SNK_25nA_1, IBIAS_SNK_25nA_2, ICONST_75A, VFB, VREF;
    output floop_out, EN_UVLO_1V2;
    inout VPWR, GND, AVSS, PBKG, FUN_DC, ISO, MOST_POS, VDD_1V2, VDD_1V2_EXT, V_SUPPLY;
    electrical VPWR, GND, floop_out, floop_in, EN_UVLO_1V2, IBIAS_SNK_25nA_0, IBIAS_SNK_25nA_1, IBIAS_SNK_25nA_2, ICONST_75A, VFB, VREF, AVSS, PBKG, FUN_DC, ISO, MOST_POS, VDD_1V2, VDD_1V2_EXT, V_SUPPLY;

    // Corner/meta parameters (equation inputs with
    // no physical pin — override per simulated corner)
    parameter real meta_corner = 8.27796e-10;
    parameter real meta_temp = -4.29365;
    parameter real meta_vsup_max = 5.04993;
    parameter real t_transition = 0.000200001;

    // Supply-sensitive logic pins (mixed-signal
    // boundary via attribute annotation, no V()
    // threshold needed — see _va_guard).
    input (* integer supplySensitivity = "V_SUPPLY"; integer groundSensitivity = "GND"; *) EN_LDO;
    logic EN_LDO;
    input (* integer supplySensitivity = "V_SUPPLY"; integer groundSensitivity = "GND"; *) VPWR_SEL;
    logic VPWR_SEL;
    input (* integer supplySensitivity = "V_SUPPLY"; integer groundSensitivity = "GND"; *) PAD_VDD1V2_SEL;
    logic PAD_VDD1V2_SEL;
    input (* integer supplySensitivity = "V_SUPPLY"; integer groundSensitivity = "GND"; *) UVLO_GD_OR_OVERRIDE_MPOS;
    logic UVLO_GD_OR_OVERRIDE_MPOS;
    input (* integer supplySensitivity = "V_SUPPLY"; integer groundSensitivity = "GND"; *) HIGH_POWER_MODE;
    logic HIGH_POWER_MODE;
    input (* integer supplySensitivity = "V_SUPPLY"; integer groundSensitivity = "GND"; *) SCAN_MODE_VSUPPLY;
    logic SCAN_MODE_VSUPPLY;
    input (* integer supplySensitivity = "V_SUPPLY"; integer groundSensitivity = "GND"; *) EN_SCAN_MODE_MPOS;
    logic EN_SCAN_MODE_MPOS;
    input (* integer supplySensitivity = "V_SUPPLY"; integer groundSensitivity = "GND"; *) FS_V_SUPPLY_TO_MOST_POS;
    logic FS_V_SUPPLY_TO_MOST_POS;
    input (* integer supplySensitivity = "V_SUPPLY"; integer groundSensitivity = "GND"; *) SREF_ADD_LDO1V2_LOAD_MPOS;
    logic SREF_ADD_LDO1V2_LOAD_MPOS;
    input (* integer supplySensitivity = "V_SUPPLY"; integer groundSensitivity = "GND"; *) SREF_EN_ISENSE_LDO1V2_MPOS;
    logic SREF_EN_ISENSE_LDO1V2_MPOS;
    input (* integer supplySensitivity = "V_SUPPLY"; integer groundSensitivity = "GND"; *) SREF_LDO_ISNS_DIS_MPOS;
    logic SREF_LDO_ISNS_DIS_MPOS;

    parameter integer DISABLED = 0;
    parameter integer REGULATION = 1;
    parameter integer REGULATION_2 = 2;
    parameter integer REGULATION_3 = 3;
    parameter integer REGULATION_4 = 4;
    parameter integer REGULATION_5 = 5;
    parameter integer DISABLED_2 = 6;
    parameter integer REGULATION_6 = 7;
    parameter integer REGULATION_7 = 8;
    parameter integer REGULATION_8 = 9;
    parameter integer REGULATION_9 = 10;
    parameter integer REGULATION_10 = 11;
    parameter integer REGULATION_11 = 12;
    parameter integer REGULATION_12 = 13;

    integer current_state;  // digital-domain FSM state

    analog begin

        @(initial_step) begin
            current_state = 0;
        end

        // ── Pin operating-range self-checks ──
        if ((V(VPWR) < 4.5) || (V(VPWR) > 5.5))
            $strobe("[%m] VPWR out of range: %g (expected [4.5, 5.5] voltage)", V(VPWR));
        if ((V(GND) < -0.1) || (V(GND) > 0.1))
            $strobe("[%m] GND out of range: %g (expected [-0.1, 0.1] voltage)", V(GND));
        if ((I(IBIAS_SNK_25nA_0) < 0) || (I(IBIAS_SNK_25nA_0) > 3e-08))
            $strobe("[%m] IBIAS_SNK_25nA_0 out of range: %g (expected [0, 3e-08] current)", I(IBIAS_SNK_25nA_0));
        if ((I(IBIAS_SNK_25nA_1) < 0) || (I(IBIAS_SNK_25nA_1) > 3e-08))
            $strobe("[%m] IBIAS_SNK_25nA_1 out of range: %g (expected [0, 3e-08] current)", I(IBIAS_SNK_25nA_1));
        if ((I(IBIAS_SNK_25nA_2) < 0) || (I(IBIAS_SNK_25nA_2) > 3e-08))
            $strobe("[%m] IBIAS_SNK_25nA_2 out of range: %g (expected [0, 3e-08] current)", I(IBIAS_SNK_25nA_2));
        if ((I(ICONST_75A) < 0) || (I(ICONST_75A) > 0.9))
            $strobe("[%m] ICONST_75A out of range: %g (expected [0, 0.9] current)", I(ICONST_75A));
        if ((V(AVSS) < -0.1) || (V(AVSS) > 0.1))
            $strobe("[%m] AVSS out of range: %g (expected [-0.1, 0.1] voltage)", V(AVSS));
        if ((V(PBKG) < -0.1) || (V(PBKG) > 0.1))
            $strobe("[%m] PBKG out of range: %g (expected [-0.1, 0.1] voltage)", V(PBKG));
        if ((V(FUN_DC) < 4.5) || (V(FUN_DC) > 5.5))
            $strobe("[%m] FUN_DC out of range: %g (expected [4.5, 5.5] voltage)", V(FUN_DC));
        if ((V(ISO) < 4.5) || (V(ISO) > 5.5))
            $strobe("[%m] ISO out of range: %g (expected [4.5, 5.5] voltage)", V(ISO));
        if ((V(MOST_POS) < 4.5) || (V(MOST_POS) > 5.5))
            $strobe("[%m] MOST_POS out of range: %g (expected [4.5, 5.5] voltage)", V(MOST_POS));
        if ((V(VDD_1V2) < 1.1) || (V(VDD_1V2) > 1.3))
            $strobe("[%m] VDD_1V2 out of range: %g (expected [1.1, 1.3] voltage)", V(VDD_1V2));
        if ((V(VDD_1V2_EXT) < 1.1) || (V(VDD_1V2_EXT) > 1.3))
            $strobe("[%m] VDD_1V2_EXT out of range: %g (expected [1.1, 1.3] voltage)", V(VDD_1V2_EXT));
        if ((V(V_SUPPLY) < 4.5) || (V(V_SUPPLY) > 5.5))
            $strobe("[%m] V_SUPPLY out of range: %g (expected [4.5, 5.5] voltage)", V(V_SUPPLY));

        // ── Digital-domain state-transition logic ──
        case (current_state)
            DISABLED: begin
                // condition: EN_LDO == 1
                if (EN_LDO)
                    current_state = REGULATION;
            end
            REGULATION: begin
                // condition: EN_LDO == 0
                // condition: HIGH_POWER_MODE == 1
                if (!EN_LDO && HIGH_POWER_MODE)
                    current_state = DISABLED_2;
                // condition: SREF_ADD_LDO1V2_LOAD_MPOS == 1
                // condition: VPWR_SEL == 0
                else if (SREF_ADD_LDO1V2_LOAD_MPOS && !VPWR_SEL)
                    current_state = REGULATION_11;
                // condition: EN_LDO == 0
                else if (!EN_LDO)
                    current_state = DISABLED;
                // condition: VPWR_SEL == 0
                else if (!VPWR_SEL)
                    current_state = REGULATION_2;
                // condition: HIGH_POWER_MODE == 1
                else if (HIGH_POWER_MODE)
                    current_state = REGULATION_5;
                // condition: SCAN_MODE_VSUPPLY == 1
                else if (SCAN_MODE_VSUPPLY)
                    current_state = REGULATION_6;
            end
            REGULATION_2: begin
                // condition: HIGH_POWER_MODE == 1
                // condition: VPWR_SEL == 1
                if (HIGH_POWER_MODE && VPWR_SEL)
                    current_state = REGULATION_5;
                // condition: VPWR_SEL == 1
                else if (VPWR_SEL)
                    current_state = REGULATION;
                // condition: HIGH_POWER_MODE == 1
                else if (HIGH_POWER_MODE)
                    current_state = REGULATION_3;
                // condition: SREF_ADD_LDO1V2_LOAD_MPOS == 1
                else if (SREF_ADD_LDO1V2_LOAD_MPOS)
                    current_state = REGULATION_11;
            end
            REGULATION_3: begin
                // condition: SREF_ADD_LDO1V2_LOAD_MPOS == 1
                if (SREF_ADD_LDO1V2_LOAD_MPOS)
                    current_state = REGULATION_4;
                // condition: VPWR_SEL == 1
                else if (VPWR_SEL)
                    current_state = REGULATION_5;
            end
            REGULATION_4: begin
                // condition: HIGH_POWER_MODE == 0
                // condition: SREF_ADD_LDO1V2_LOAD_MPOS == 0
                if (!HIGH_POWER_MODE && !SREF_ADD_LDO1V2_LOAD_MPOS)
                    current_state = REGULATION_2;
            end
            REGULATION_5: begin
                // condition: HIGH_POWER_MODE == 0
                if (!HIGH_POWER_MODE)
                    current_state = REGULATION;
            end
            DISABLED_2: begin
                // condition: EN_LDO == 1
                if (EN_LDO)
                    current_state = REGULATION_5;
            end
            REGULATION_6: begin
                // condition: EN_SCAN_MODE_MPOS == 1
                // condition: SCAN_MODE_VSUPPLY == 0
                if (EN_SCAN_MODE_MPOS && !SCAN_MODE_VSUPPLY)
                    current_state = REGULATION_7;
            end
            REGULATION_7: begin
                // condition: SCAN_MODE_VSUPPLY == 1
                if (SCAN_MODE_VSUPPLY)
                    current_state = REGULATION_8;
            end
            REGULATION_8: begin
                // condition: SREF_ADD_LDO1V2_LOAD_MPOS == 1
                if (SREF_ADD_LDO1V2_LOAD_MPOS)
                    current_state = REGULATION_9;
            end
            REGULATION_9: begin
                // condition: EN_SCAN_MODE_MPOS == 0
                // condition: SCAN_MODE_VSUPPLY == 0
                if (!EN_SCAN_MODE_MPOS && !SCAN_MODE_VSUPPLY)
                    current_state = REGULATION_10;
            end
            REGULATION_10: begin
                // condition: SREF_ADD_LDO1V2_LOAD_MPOS == 0
                if (!SREF_ADD_LDO1V2_LOAD_MPOS)
                    current_state = REGULATION;
            end
            REGULATION_11: begin
                // condition: EN_SCAN_MODE_MPOS == 1
                // condition: SCAN_MODE_VSUPPLY == 1
                if (EN_SCAN_MODE_MPOS && SCAN_MODE_VSUPPLY)
                    current_state = REGULATION_12;
            end
            REGULATION_12: begin
                // condition: EN_SCAN_MODE_MPOS == 0
                // condition: SCAN_MODE_VSUPPLY == 0
                // condition: SREF_ADD_LDO1V2_LOAD_MPOS == 0
                if (!EN_SCAN_MODE_MPOS && !SCAN_MODE_VSUPPLY && !SREF_ADD_LDO1V2_LOAD_MPOS)
                    current_state = REGULATION_2;
            end
        endcase

        // ── Fitted per-state output equations (Phase 2 modeling) ──
        case (current_state)
            DISABLED: begin
                I(FUN_DC, GND) <+ transition(PBKG_I * 0.40281367, 0, t_transition, t_transition);  // FUN_DC_I
                V(VDD_1V2) <+ transition((exp(ISO_I * -92.316734) - 0.9154745) * 1.6992617, 0, t_transition, t_transition);
                I(VPWR, GND) <+ transition(((VDD_1V2_I / -0.85714936) - PBKG_I) - (AVSS_I + MOST_POS_I), 0, t_transition, t_transition);  // VPWR_I
                I(V_SUPPLY, GND) <+ transition(V(FUN_DC) * 2.8801762e-5, 0, t_transition, t_transition);  // V_SUPPLY_I
            end
            REGULATION: begin
                I(FUN_DC, GND) <+ transition(idt(I(floop_out, GND)) * 23089.334, 0, t_transition, t_transition);  // FUN_DC_I
                V(VDD_1V2) <+ transition((ISO_I * -58.325542) + 0.87574404, 0, t_transition, t_transition);
                I(VPWR, GND) <+ transition((VDD_1V2_I * -0.9937707) - (AVSS_I / exp(AVSS_I + AVSS_I)), 0, t_transition, t_transition);  // VPWR_I
                I(V_SUPPLY, GND) <+ transition(VDD_1V2_I * -0.00038813215, 0, t_transition, t_transition);  // V_SUPPLY_I
            end
            REGULATION_2: begin
                I(FUN_DC, GND) <+ transition((AVSS_I + VDD_1V2_I) * -0.6725917, 0, t_transition, t_transition);  // FUN_DC_I
                V(VDD_1V2) <+ transition((ISO_I * -65.526985) - -1.0123514, 0, t_transition, t_transition);
                I(VPWR, GND) <+ transition(idt(V(MOST_POS)) * ((VDD_1V2_I + AVSS_I) / -0.3152533), 0, t_transition, t_transition);  // VPWR_I
                I(V_SUPPLY, GND) <+ transition(((-5.7626266e-7 / meta_corner) / -0.20209794) - (log(meta_vsup_max) * -6.6513e-5), 0, t_transition, t_transition);  // V_SUPPLY_I
            end
            REGULATION_3: begin
                I(FUN_DC, GND) <+ transition(idt(I(VDD_1V2, GND)) - (VDD_1V2_I * exp(idt(I(AVSS, GND)) / (idt(I(VDD_1V2, GND)) / 4.6620555))), 0, t_transition, t_transition);  // FUN_DC_I
                V(VDD_1V2) <+ transition((ISO_I * -286.98157) + 0.8796061, 0, t_transition, t_transition);
                I(VPWR, GND) <+ transition(VDD_1V2_I * ((idt(V(VPWR)) - idt(V(V_SUPPLY))) * 112.315346), 0, t_transition, t_transition);  // VPWR_I
                I(V_SUPPLY, GND) <+ transition(idt(I(AVSS, GND)) * 0.3393371, 0, t_transition, t_transition);  // V_SUPPLY_I
            end
            REGULATION_4: begin
                I(FUN_DC, GND) <+ transition((0.00021563028 - VDD_1V2_I) + (ISO_I * -0.6881471), 0, t_transition, t_transition);  // FUN_DC_I
                V(VDD_1V2) <+ transition(((8.234361 / V(V_SUPPLY)) + -0.80329573) + (ISO_I * -300.20877), 0, t_transition, t_transition);
                I(VPWR, GND) <+ transition((VDD_1V2_I * 817.28345) * idt(I(MOST_POS, GND)), 0, t_transition, t_transition);  // VPWR_I
                I(V_SUPPLY, GND) <+ transition((1.1258842 * ((-0.6003273 * floop_out_I) / (-0.15424047 + idt(V(MOST_POS))))) / idt(V(MOST_POS)), 0, t_transition, t_transition);  // V_SUPPLY_I
            end
            REGULATION_5: begin
                I(FUN_DC, GND) <+ transition((((idt(I(MOST_POS, GND)) * V(V_SUPPLY)) / idt(V(V_SUPPLY))) / (meta_corner + -0.788054)) - -4.3131868e-6, 0, t_transition, t_transition);  // FUN_DC_I
                V(VDD_1V2) <+ transition((2.2370858 / exp(ISO_I * 182.62665)) + -1.485869, 0, t_transition, t_transition);
                I(VPWR, GND) <+ transition((VDD_1V2_I / -1.0022407) - (AVSS_I / (AVSS_I + exp(AVSS_I))), 0, t_transition, t_transition);  // VPWR_I
                I(V_SUPPLY, GND) <+ transition(4.6029795e-6 - (PBKG_I * VDD_1V2_I), 0, t_transition, t_transition);  // V_SUPPLY_I
            end
            DISABLED_2: begin
                I(FUN_DC, GND) <+ transition(PBKG_I * 0.45149, 0, t_transition, t_transition);  // FUN_DC_I
                V(VDD_1V2) <+ transition((((ISO_I - 0.01481444) * -0.0026508651) / idt(I(AVSS, GND))) + -1.3438823, 0, t_transition, t_transition);
                I(VPWR, GND) <+ transition((MOST_POS_I * -1.2247722) - ((VDD_1V2_I + AVSS_I) - (V(V_SUPPLY) * idt(I(AVSS, GND)))), 0, t_transition, t_transition);  // VPWR_I
                I(V_SUPPLY, GND) <+ transition((exp(meta_corner) * 3.8215534e-5) * V(V_SUPPLY), 0, t_transition, t_transition);  // V_SUPPLY_I
            end
            REGULATION_6: begin
                I(FUN_DC, GND) <+ transition(((idt(I(MOST_POS, GND)) * V(V_SUPPLY)) + -4.921449e-7) / (meta_corner * 1.5008647), 0, t_transition, t_transition);  // FUN_DC_I
                V(VDD_1V2) <+ transition((meta_vsup_max / 4.9021754) + (ISO_I * -57.871166), 0, t_transition, t_transition);
                I(VPWR, GND) <+ transition((AVSS_I * 0.15525495) - (AVSS_I + VDD_1V2_I), 0, t_transition, t_transition);  // VPWR_I
                I(V_SUPPLY, GND) <+ transition((idt(I(ISO, GND)) * (VDD_1V2_EXT_I * exp(V(V_SUPPLY) * V(V_SUPPLY)))) * 6.4329797e-10, 0, t_transition, t_transition);  // V_SUPPLY_I
            end
            REGULATION_7: begin
                I(FUN_DC, GND) <+ transition(2.2512965 * (((6.2314035e-7 - (V(MOST_POS) * idt(I(MOST_POS, GND)))) * V(V_SUPPLY)) - idt(I(PBKG, GND))), 0, t_transition, t_transition);  // FUN_DC_I
                V(VDD_1V2) <+ transition((ISO_I - 0.017328277) * (V(VPWR) / -0.08719268), 0, t_transition, t_transition);
                I(VPWR, GND) <+ transition(sqrt((VDD_1V2_I * -0.014013443) - idt(I(AVSS, GND))), 0, t_transition, t_transition);  // VPWR_I
                I(V_SUPPLY, GND) <+ transition(exp(V(V_SUPPLY) * ((V(V_SUPPLY) * 0.034123894) * V(V_SUPPLY))) * idt(I(VDD_1V2_EXT, GND)), 0, t_transition, t_transition);  // V_SUPPLY_I
            end
            REGULATION_8: begin
                I(FUN_DC, GND) <+ transition((exp(V(FUN_DC)) * -6.453324e-8) - -1.3888155e-5, 0, t_transition, t_transition);  // FUN_DC_I
                V(VDD_1V2) <+ transition(((AVSS_I * -28.876953) + (V(V_SUPPLY) * 0.45814657)) + -1.4223986, 0, t_transition, t_transition);
                I(VPWR, GND) <+ transition(0.024844825 + (0.00014386806 / VDD_1V2_I), 0, t_transition, t_transition);  // VPWR_I
                I(V_SUPPLY, GND) <+ transition((exp(V(FUN_DC)) - 92.63703) * idt(I(VDD_1V2_EXT, GND)), 0, t_transition, t_transition);  // V_SUPPLY_I
            end
            REGULATION_9: begin
                I(FUN_DC, GND) <+ transition(idt(I(MOST_POS, GND)) * -10.5617485, 0, t_transition, t_transition);  // FUN_DC_I
                V(VDD_1V2) <+ transition((-0.0006559592 / idt(I(VDD_1V2, GND))) + -1.8343569, 0, t_transition, t_transition);
                I(VPWR, GND) <+ transition((PBKG_I * meta_temp) + 0.015498941, 0, t_transition, t_transition);  // VPWR_I
                I(V_SUPPLY, GND) <+ transition(((idt(I(VDD_1V2_EXT, GND)) * 5.3763216e-11) * idt(V(VPWR))) * exp(meta_vsup_max * meta_vsup_max), 0, t_transition, t_transition);  // V_SUPPLY_I
            end
            REGULATION_10: begin
                I(FUN_DC, GND) <+ transition(idt(I(floop_out, GND)) * -25274.809, 0, t_transition, t_transition);  // FUN_DC_I
                V(VDD_1V2) <+ transition((-0.040777314 / VDD_1V2_I) + -1.886805, 0, t_transition, t_transition);
                I(VPWR, GND) <+ transition((idt(I(AVSS, GND)) + (((idt(I(PBKG, GND)) * meta_temp) / 0.13117203) + 0.0027573549)) * V(VPWR), 0, t_transition, t_transition);  // VPWR_I
                I(V_SUPPLY, GND) <+ transition(idt(I(VDD_1V2_EXT, GND)) * (exp(meta_vsup_max * meta_vsup_max) * 1.0971181e-11), 0, t_transition, t_transition);  // V_SUPPLY_I
            end
            REGULATION_11: begin
                I(FUN_DC, GND) <+ transition((idt(V(V_SUPPLY)) * 2.8841445) ^ V(MOST_POS), 0, t_transition, t_transition);  // FUN_DC_I
                V(VDD_1V2) <+ transition(0.5943706 - ((meta_temp * -0.0045121037) + (ISO_I * 52.151623)), 0, t_transition, t_transition);
                I(VPWR, GND) <+ transition(MOST_POS_I * -0.44996902, 0, t_transition, t_transition);  // VPWR_I
                I(V_SUPPLY, GND) <+ transition(((V(FUN_DC) * 2.9791503e-5) / idt(V(MOST_POS))) - 0.0009558587, 0, t_transition, t_transition);  // V_SUPPLY_I
            end
            REGULATION_12: begin
                I(FUN_DC, GND) <+ transition((((0.13109495 - AVSS_I) * VDD_1V2_I) * -7.9331098) - (ISO_I * 0.2852467), 0, t_transition, t_transition);  // FUN_DC_I
                V(VDD_1V2) <+ transition(0.04416584 / (VDD_1V2_I + 0.0642903), 0, t_transition, t_transition);
                I(VPWR, GND) <+ transition(-0.0001821667 / meta_temp, 0, t_transition, t_transition);  // VPWR_I
                I(V_SUPPLY, GND) <+ transition(idt(V(VPWR)) * (exp(idt(V(VPWR)) * (V(MOST_POS) * V(FUN_DC))) * idt(I(VDD_1V2_EXT, GND))), 0, t_transition, t_transition);  // V_SUPPLY_I
            end
            default: ;
        endcase

        V(EN_UVLO_1V2) <+ ((current_state == REGULATION) || (current_state == REGULATION_2) || (current_state == REGULATION_3) || (current_state == REGULATION_4) || (current_state == REGULATION_5) || (current_state == REGULATION_6) || (current_state == REGULATION_7) || (current_state == REGULATION_8) || (current_state == REGULATION_9) || (current_state == REGULATION_10) || (current_state == REGULATION_11) || (current_state == REGULATION_12)) ? 5.5 : 0.0;

    end  // analog begin

endmodule

// Auto-generated Verilog-A FSM — LDO
// Generated by surrogate_framework FSMCodeGenerator

`include "disciplines.vams"
`include "constants.vams"

module ldo_fsm_model(
    VPWR, GND, floop_out, floop_in, EN_LDO, EN_UVLO_1V2, VPWR_SEL, PAD_VDD1V2_SEL, UVLO_GD_OR_OVERRIDE_MPOS, HIGH_POWER_MODE, SCAN_MODE_VSUPPLY, EN_SCAN_MODE_MPOS, FS_V_SUPPLY_TO_MOST_POS, SREF_ADD_LDO1V2_LOAD_MPOS, SREF_EN_ISENSE_LDO1V2_MPOS, SREF_LDO_ISNS_DIS_MPOS, IBIAS_SNK_25nA_0, IBIAS_SNK_25nA_1, IBIAS_SNK_25nA_2, ICONST_75A, VFB, VREF, AVSS, PBKG, FUN_DC, ISO, MOST_POS, VDD_1V2, VDD_1V2_EXT, V_SUPPLY
);

    input floop_in, EN_LDO, VPWR_SEL, PAD_VDD1V2_SEL, UVLO_GD_OR_OVERRIDE_MPOS, HIGH_POWER_MODE, SCAN_MODE_VSUPPLY, EN_SCAN_MODE_MPOS, FS_V_SUPPLY_TO_MOST_POS, SREF_ADD_LDO1V2_LOAD_MPOS, SREF_EN_ISENSE_LDO1V2_MPOS, SREF_LDO_ISNS_DIS_MPOS, IBIAS_SNK_25nA_0, IBIAS_SNK_25nA_1, IBIAS_SNK_25nA_2, ICONST_75A, VFB, VREF;
    output floop_out, EN_UVLO_1V2;
    inout VPWR, GND, AVSS, PBKG, FUN_DC, ISO, MOST_POS, VDD_1V2, VDD_1V2_EXT, V_SUPPLY;
    electrical VPWR, GND, floop_out, floop_in, EN_LDO, EN_UVLO_1V2, VPWR_SEL, PAD_VDD1V2_SEL, UVLO_GD_OR_OVERRIDE_MPOS, HIGH_POWER_MODE, SCAN_MODE_VSUPPLY, EN_SCAN_MODE_MPOS, FS_V_SUPPLY_TO_MOST_POS, SREF_ADD_LDO1V2_LOAD_MPOS, SREF_EN_ISENSE_LDO1V2_MPOS, SREF_LDO_ISNS_DIS_MPOS, IBIAS_SNK_25nA_0, IBIAS_SNK_25nA_1, IBIAS_SNK_25nA_2, ICONST_75A, VFB, VREF, AVSS, PBKG, FUN_DC, ISO, MOST_POS, VDD_1V2, VDD_1V2_EXT, V_SUPPLY;

    parameter real VTH_EN_LDO = 2.75;  // logic threshold for EN_LDO
    parameter real VTH_EN_SCAN_MODE_MPOS = 2.75;  // logic threshold for EN_SCAN_MODE_MPOS
    parameter real VTH_VPWR_SEL = 2.75;  // logic threshold for VPWR_SEL

    parameter integer DISABLED = 0;
    parameter integer STARTUP = 1;
    parameter integer STARTUP_2 = 2;
    parameter integer STARTUP_3 = 3;
    parameter integer STARTUP_4 = 4;

    integer current_state;

    analog begin

        @(initial_step) begin
            current_state = 0;
        end

        case (current_state)
            DISABLED: begin
                // condition: EN_LDO == 1
                if (V(EN_LDO) > VTH_EN_LDO)
                    current_state = STARTUP;
            end
            STARTUP: begin
                // condition: EN_SCAN_MODE_MPOS == 1
                if (V(EN_SCAN_MODE_MPOS) > VTH_EN_SCAN_MODE_MPOS)
                    current_state = STARTUP_2;
                // condition: VPWR_SEL == 0
                else if (V(VPWR_SEL) < VTH_VPWR_SEL)
                    current_state = STARTUP_3;
            end
            STARTUP_2: begin
                // condition: EN_SCAN_MODE_MPOS == 0
                if (V(EN_SCAN_MODE_MPOS) < VTH_EN_SCAN_MODE_MPOS)
                    current_state = STARTUP;
            end
            STARTUP_3: begin
                // condition: EN_SCAN_MODE_MPOS == 1
                if (V(EN_SCAN_MODE_MPOS) > VTH_EN_SCAN_MODE_MPOS)
                    current_state = STARTUP_4;
            end
            STARTUP_4: begin
                // condition: EN_SCAN_MODE_MPOS == 0
                if (V(EN_SCAN_MODE_MPOS) < VTH_EN_SCAN_MODE_MPOS)
                    current_state = STARTUP_3;
            end
        endcase

    end  // analog begin

endmodule

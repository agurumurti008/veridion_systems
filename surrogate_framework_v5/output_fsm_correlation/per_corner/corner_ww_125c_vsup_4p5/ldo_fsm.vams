// Auto-generated Verilog-A FSM — LDO
// Generated by surrogate_framework FSMCodeGenerator

`include "disciplines.vams"
`include "constants.vams"

module ldo_fsm_model(
    VPWR, GND, floop_out, floop_in, EN_LDO, EN_UVLO_1V2, VPWR_SEL, PAD_VDD1V2_SEL, UVLO_GD_OR_OVERRIDE_MPOS, HIGH_POWER_MODE, SCAN_MODE_VSUPPLY, EN_SCAN_MODE_MPOS, FS_V_SUPPLY_TO_MOST_POS, SREF_ADD_LDO1V2_LOAD_MPOS, SREF_EN_ISENSE_LDO1V2_MPOS, SREF_LDO_ISNS_DIS_MPOS, IBIAS_SNK_25nA_0, IBIAS_SNK_25nA_1, IBIAS_SNK_25nA_2, ICONST_75A, VFB, VREF, AVSS, PBKG, FUN_DC, ISO, MOST_POS, VDD_1V2, VDD_1V2_EXT, V_SUPPLY
);

    input floop_in, EN_LDO, VPWR_SEL, PAD_VDD1V2_SEL, UVLO_GD_OR_OVERRIDE_MPOS, HIGH_POWER_MODE, SCAN_MODE_VSUPPLY, EN_SCAN_MODE_MPOS, FS_V_SUPPLY_TO_MOST_POS, SREF_ADD_LDO1V2_LOAD_MPOS, SREF_EN_ISENSE_LDO1V2_MPOS, SREF_LDO_ISNS_DIS_MPOS, IBIAS_SNK_25nA_0, IBIAS_SNK_25nA_1, IBIAS_SNK_25nA_2, ICONST_75A, VFB, VREF;
    output floop_out, EN_UVLO_1V2;
    inout VPWR, GND, AVSS, PBKG, FUN_DC, ISO, MOST_POS, VDD_1V2, VDD_1V2_EXT, V_SUPPLY;
    electrical VPWR, GND, floop_out, floop_in, EN_LDO, EN_UVLO_1V2, VPWR_SEL, PAD_VDD1V2_SEL, UVLO_GD_OR_OVERRIDE_MPOS, HIGH_POWER_MODE, SCAN_MODE_VSUPPLY, EN_SCAN_MODE_MPOS, FS_V_SUPPLY_TO_MOST_POS, SREF_ADD_LDO1V2_LOAD_MPOS, SREF_EN_ISENSE_LDO1V2_MPOS, SREF_LDO_ISNS_DIS_MPOS, IBIAS_SNK_25nA_0, IBIAS_SNK_25nA_1, IBIAS_SNK_25nA_2, ICONST_75A, VFB, VREF, AVSS, PBKG, FUN_DC, ISO, MOST_POS, VDD_1V2, VDD_1V2_EXT, V_SUPPLY;

    parameter real VTH_EN_SCAN_MODE_MPOS = 2.75;  // logic threshold for EN_SCAN_MODE_MPOS
    parameter real VTH_SCAN_MODE_VSUPPLY = 2.75;  // logic threshold for SCAN_MODE_VSUPPLY
    parameter real VTH_SREF_ADD_LDO1V2_LOAD_MPOS = 2.75;  // logic threshold for SREF_ADD_LDO1V2_LOAD_MPOS

    parameter integer REGULATION = 0;
    parameter integer REGULATION_2 = 1;
    parameter integer REGULATION_3 = 2;
    parameter integer REGULATION_4 = 3;
    parameter integer REGULATION_5 = 4;
    parameter integer REGULATION_6 = 5;

    integer current_state;

    analog begin

        @(initial_step) begin
            current_state = 0;
        end

        case (current_state)
            REGULATION: begin
                // condition: SCAN_MODE_VSUPPLY == 1
                if (V(SCAN_MODE_VSUPPLY) > VTH_SCAN_MODE_VSUPPLY)
                    current_state = REGULATION_2;
                // condition: SREF_ADD_LDO1V2_LOAD_MPOS == 1
                else if (V(SREF_ADD_LDO1V2_LOAD_MPOS) > VTH_SREF_ADD_LDO1V2_LOAD_MPOS)
                    current_state = REGULATION_6;
            end
            REGULATION_2: begin
                // condition: EN_SCAN_MODE_MPOS == 1
                // condition: SCAN_MODE_VSUPPLY == 0
                if (V(EN_SCAN_MODE_MPOS) > VTH_EN_SCAN_MODE_MPOS && V(SCAN_MODE_VSUPPLY) < VTH_SCAN_MODE_VSUPPLY)
                    current_state = REGULATION_3;
            end
            REGULATION_3: begin
                // condition: SCAN_MODE_VSUPPLY == 1
                if (V(SCAN_MODE_VSUPPLY) > VTH_SCAN_MODE_VSUPPLY)
                    current_state = REGULATION_4;
            end
            REGULATION_4: begin
                // condition: SREF_ADD_LDO1V2_LOAD_MPOS == 1
                if (V(SREF_ADD_LDO1V2_LOAD_MPOS) > VTH_SREF_ADD_LDO1V2_LOAD_MPOS)
                    current_state = REGULATION_5;
            end
            REGULATION_5: begin
                // condition: EN_SCAN_MODE_MPOS == 0
                // condition: SCAN_MODE_VSUPPLY == 0
                // condition: SREF_ADD_LDO1V2_LOAD_MPOS == 0
                if (V(EN_SCAN_MODE_MPOS) < VTH_EN_SCAN_MODE_MPOS && V(SCAN_MODE_VSUPPLY) < VTH_SCAN_MODE_VSUPPLY && V(SREF_ADD_LDO1V2_LOAD_MPOS) < VTH_SREF_ADD_LDO1V2_LOAD_MPOS)
                    current_state = REGULATION;
                // condition: EN_SCAN_MODE_MPOS == 0
                // condition: SCAN_MODE_VSUPPLY == 0
                else if (V(EN_SCAN_MODE_MPOS) < VTH_EN_SCAN_MODE_MPOS && V(SCAN_MODE_VSUPPLY) < VTH_SCAN_MODE_VSUPPLY)
                    current_state = REGULATION_6;
            end
            REGULATION_6: begin
                // condition: EN_SCAN_MODE_MPOS == 1
                // condition: SCAN_MODE_VSUPPLY == 1
                if (V(EN_SCAN_MODE_MPOS) > VTH_EN_SCAN_MODE_MPOS && V(SCAN_MODE_VSUPPLY) > VTH_SCAN_MODE_VSUPPLY)
                    current_state = REGULATION_5;
                // condition: SREF_ADD_LDO1V2_LOAD_MPOS == 0
                else if (V(SREF_ADD_LDO1V2_LOAD_MPOS) < VTH_SREF_ADD_LDO1V2_LOAD_MPOS)
                    current_state = REGULATION;
            end
        endcase

        V(EN_UVLO_1V2) <+ ((current_state == REGULATION) || (current_state == REGULATION_2) || (current_state == REGULATION_3) || (current_state == REGULATION_4) || (current_state == REGULATION_5) || (current_state == REGULATION_6)) ? 5.5 : 0.0;

    end  // analog begin

endmodule

// Auto-generated Verilog-A FSM — LDO
// Generated by surrogate_framework FSMCodeGenerator

`include "disciplines.vams"
`include "constants.vams"

module ldo_fsm_model(
    VPWR, GND, floop_out, floop_in, EN_LDO, EN_UVLO_1V2, VPWR_SEL, PAD_VDD1V2_SEL, UVLO_GD_OR_OVERRIDE_MPOS, HIGH_POWER_MODE, SCAN_MODE_VSUPPLY, EN_SCAN_MODE_MPOS, FS_V_SUPPLY_TO_MOST_POS, SREF_ADD_LDO1V2_LOAD_MPOS, SREF_EN_ISENSE_LDO1V2_MPOS, SREF_LDO_ISNS_DIS_MPOS, IBIAS_SNK_25nA_0, IBIAS_SNK_25nA_1, IBIAS_SNK_25nA_2, ICONST_75A, VFB, VREF, AVSS, PBKG, FUN_DC, ISO, MOST_POS, VDD_1V2, VDD_1V2_EXT, V_SUPPLY
);

    input floop_in, EN_LDO, VPWR_SEL, PAD_VDD1V2_SEL, UVLO_GD_OR_OVERRIDE_MPOS, HIGH_POWER_MODE, SCAN_MODE_VSUPPLY, EN_SCAN_MODE_MPOS, FS_V_SUPPLY_TO_MOST_POS, SREF_ADD_LDO1V2_LOAD_MPOS, SREF_EN_ISENSE_LDO1V2_MPOS, SREF_LDO_ISNS_DIS_MPOS, IBIAS_SNK_25nA_0, IBIAS_SNK_25nA_1, IBIAS_SNK_25nA_2, ICONST_75A, VFB, VREF;
    output floop_out, EN_UVLO_1V2;
    inout VPWR, GND, AVSS, PBKG, FUN_DC, ISO, MOST_POS, VDD_1V2, VDD_1V2_EXT, V_SUPPLY;
    electrical VPWR, GND, floop_out, floop_in, EN_LDO, EN_UVLO_1V2, VPWR_SEL, PAD_VDD1V2_SEL, UVLO_GD_OR_OVERRIDE_MPOS, HIGH_POWER_MODE, SCAN_MODE_VSUPPLY, EN_SCAN_MODE_MPOS, FS_V_SUPPLY_TO_MOST_POS, SREF_ADD_LDO1V2_LOAD_MPOS, SREF_EN_ISENSE_LDO1V2_MPOS, SREF_LDO_ISNS_DIS_MPOS, IBIAS_SNK_25nA_0, IBIAS_SNK_25nA_1, IBIAS_SNK_25nA_2, ICONST_75A, VFB, VREF, AVSS, PBKG, FUN_DC, ISO, MOST_POS, VDD_1V2, VDD_1V2_EXT, V_SUPPLY;

    parameter real VTH_HIGH_POWER_MODE = 2.75;  // logic threshold for HIGH_POWER_MODE
    parameter real VTH_PAD_VDD1V2_SEL = 2.75;  // logic threshold for PAD_VDD1V2_SEL
    parameter real VTH_SREF_ADD_LDO1V2_LOAD_MPOS = 2.75;  // logic threshold for SREF_ADD_LDO1V2_LOAD_MPOS

    parameter integer DISABLED = 0;
    parameter integer UVLO = 1;
    parameter integer STARTUP = 2;
    parameter integer REGULATION = 3;
    parameter integer HIGH_POWER_MODE = 4;

    integer current_state;

    analog begin

        @(initial_step) begin
            current_state = 0;
        end

        case (current_state)
            DISABLED: begin
                // condition: PAD_VDD1V2_SEL == 1
                if (V(PAD_VDD1V2_SEL) > VTH_PAD_VDD1V2_SEL)
                    current_state = UVLO;
                // condition: HIGH_POWER_MODE == 1
                else if (V(HIGH_POWER_MODE) > VTH_HIGH_POWER_MODE)
                    current_state = HIGH_POWER_MODE;
            end
            UVLO: begin
                // condition: HIGH_POWER_MODE == 1
                if (V(HIGH_POWER_MODE) > VTH_HIGH_POWER_MODE)
                    current_state = STARTUP;
            end
            STARTUP: begin
                // condition: SREF_ADD_LDO1V2_LOAD_MPOS == 1
                if (V(SREF_ADD_LDO1V2_LOAD_MPOS) > VTH_SREF_ADD_LDO1V2_LOAD_MPOS)
                    current_state = REGULATION;
            end
            REGULATION: begin
                // condition: HIGH_POWER_MODE == 0
                // condition: PAD_VDD1V2_SEL == 0
                // condition: SREF_ADD_LDO1V2_LOAD_MPOS == 0
                if (V(HIGH_POWER_MODE) < VTH_HIGH_POWER_MODE && V(PAD_VDD1V2_SEL) < VTH_PAD_VDD1V2_SEL && V(SREF_ADD_LDO1V2_LOAD_MPOS) < VTH_SREF_ADD_LDO1V2_LOAD_MPOS)
                    current_state = DISABLED;
            end
            HIGH_POWER_MODE: begin
                // condition: HIGH_POWER_MODE == 0
                if (V(HIGH_POWER_MODE) < VTH_HIGH_POWER_MODE)
                    current_state = DISABLED;
            end
        endcase

        V(EN_UVLO_1V2) <+ ((current_state == REGULATION)) ? 5.5 : 0.0;

    end  // analog begin

endmodule

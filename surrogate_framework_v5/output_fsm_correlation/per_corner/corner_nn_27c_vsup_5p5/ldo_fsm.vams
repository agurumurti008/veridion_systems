// Auto-generated Verilog-A FSM — LDO
// Generated by surrogate_framework FSMCodeGenerator

`include "disciplines.vams"
`include "constants.vams"

module ldo_fsm_model(
    VPWR, GND, floop_out, floop_in, EN_LDO, EN_UVLO_1V2, VPWR_SEL, PAD_VDD1V2_SEL, UVLO_GD_OR_OVERRIDE_MPOS, HIGH_POWER_MODE, SCAN_MODE_VSUPPLY, EN_SCAN_MODE_MPOS, FS_V_SUPPLY_TO_MOST_POS, SREF_ADD_LDO1V2_LOAD_MPOS, SREF_EN_ISENSE_LDO1V2_MPOS, SREF_LDO_ISNS_DIS_MPOS, IBIAS_SNK_25nA_0, IBIAS_SNK_25nA_1, IBIAS_SNK_25nA_2, ICONST_75A, VFB, VREF, AVSS, PBKG, FUN_DC, ISO, MOST_POS, VDD_1V2, VDD_1V2_EXT, V_SUPPLY, SREF_LDO1V2_LP_TB_ICONST_75A_0_, SREF_LDO1V2_LP_TB_X_DUT_IBIAS_SNK_25nA__0_, SREF_LDO1V2_LP_TB_X_DUT_IBIAS_SNK_25nA__1_, SREF_LDO1V2_LP_TB_X_DUT_IBIAS_SNK_25nA__2_, SREF_LDO1V2_LP_TB_X_DUT_ICONST_75A_0_
);

    input floop_in, EN_LDO, VPWR_SEL, PAD_VDD1V2_SEL, UVLO_GD_OR_OVERRIDE_MPOS, HIGH_POWER_MODE, SCAN_MODE_VSUPPLY, EN_SCAN_MODE_MPOS, FS_V_SUPPLY_TO_MOST_POS, SREF_ADD_LDO1V2_LOAD_MPOS, SREF_EN_ISENSE_LDO1V2_MPOS, SREF_LDO_ISNS_DIS_MPOS, IBIAS_SNK_25nA_0, IBIAS_SNK_25nA_1, IBIAS_SNK_25nA_2, ICONST_75A, VFB, VREF, SREF_LDO1V2_LP_TB_ICONST_75A_0_, SREF_LDO1V2_LP_TB_X_DUT_IBIAS_SNK_25nA__0_, SREF_LDO1V2_LP_TB_X_DUT_IBIAS_SNK_25nA__1_, SREF_LDO1V2_LP_TB_X_DUT_IBIAS_SNK_25nA__2_, SREF_LDO1V2_LP_TB_X_DUT_ICONST_75A_0_;
    output floop_out, EN_UVLO_1V2;
    inout VPWR, GND, AVSS, PBKG, FUN_DC, ISO, MOST_POS, VDD_1V2, VDD_1V2_EXT, V_SUPPLY;
    electrical VPWR, GND, floop_out, floop_in, EN_LDO, EN_UVLO_1V2, VPWR_SEL, PAD_VDD1V2_SEL, UVLO_GD_OR_OVERRIDE_MPOS, HIGH_POWER_MODE, SCAN_MODE_VSUPPLY, EN_SCAN_MODE_MPOS, FS_V_SUPPLY_TO_MOST_POS, SREF_ADD_LDO1V2_LOAD_MPOS, SREF_EN_ISENSE_LDO1V2_MPOS, SREF_LDO_ISNS_DIS_MPOS, IBIAS_SNK_25nA_0, IBIAS_SNK_25nA_1, IBIAS_SNK_25nA_2, ICONST_75A, VFB, VREF, AVSS, PBKG, FUN_DC, ISO, MOST_POS, VDD_1V2, VDD_1V2_EXT, V_SUPPLY, SREF_LDO1V2_LP_TB_ICONST_75A_0_, SREF_LDO1V2_LP_TB_X_DUT_IBIAS_SNK_25nA__0_, SREF_LDO1V2_LP_TB_X_DUT_IBIAS_SNK_25nA__1_, SREF_LDO1V2_LP_TB_X_DUT_IBIAS_SNK_25nA__2_, SREF_LDO1V2_LP_TB_X_DUT_ICONST_75A_0_;

    parameter real VTH_SREF_LDO1V2_LP_TB_ICONST_75A_0_ = 0.5;  // logic threshold for SREF_LDO1V2_LP_TB.ICONST_75A[0]
    parameter real VTH_SREF_LDO1V2_LP_TB_X_DUT_IBIAS_SNK_25nA__0_ = 0.5;  // logic threshold for SREF_LDO1V2_LP_TB.X_DUT.IBIAS_SNK_25nA_[0]
    parameter real VTH_SREF_LDO1V2_LP_TB_X_DUT_IBIAS_SNK_25nA__1_ = 0.5;  // logic threshold for SREF_LDO1V2_LP_TB.X_DUT.IBIAS_SNK_25nA_[1]
    parameter real VTH_SREF_LDO1V2_LP_TB_X_DUT_IBIAS_SNK_25nA__2_ = 0.5;  // logic threshold for SREF_LDO1V2_LP_TB.X_DUT.IBIAS_SNK_25nA_[2]
    parameter real VTH_SREF_LDO1V2_LP_TB_X_DUT_ICONST_75A_0_ = 0.5;  // logic threshold for SREF_LDO1V2_LP_TB.X_DUT.ICONST_75A[0]

    parameter integer REGULATION = 0;
    parameter integer UVLO = 1;
    parameter integer STARTUP = 2;
    parameter integer REGULATION_2 = 3;
    parameter integer REGULATION_3 = 4;
    parameter integer REGULATION_4 = 5;
    parameter integer OVERRIDE = 6;

    integer current_state;

    analog begin

        @(initial_step) begin
            current_state = 0;
        end

        case (current_state)
            REGULATION: begin
                // condition: SREF_LDO1V2_LP_TB.X_DUT.IBIAS_SNK_25nA_[1] == 1
                if (V(SREF_LDO1V2_LP_TB_X_DUT_IBIAS_SNK_25nA__1_) > VTH_SREF_LDO1V2_LP_TB_X_DUT_IBIAS_SNK_25nA__1_)
                    current_state = UVLO;
                // condition: SREF_LDO1V2_LP_TB.X_DUT.IBIAS_SNK_25nA_[2] == 1
                else if (V(SREF_LDO1V2_LP_TB_X_DUT_IBIAS_SNK_25nA__2_) > VTH_SREF_LDO1V2_LP_TB_X_DUT_IBIAS_SNK_25nA__2_)
                    current_state = REGULATION_3;
            end
            UVLO: begin
                // condition: SREF_LDO1V2_LP_TB.ICONST_75A[0] == 1
                // condition: SREF_LDO1V2_LP_TB.X_DUT.ICONST_75A[0] == 1
                if (V(SREF_LDO1V2_LP_TB_ICONST_75A_0_) > VTH_SREF_LDO1V2_LP_TB_ICONST_75A_0_ && V(SREF_LDO1V2_LP_TB_X_DUT_ICONST_75A_0_) > VTH_SREF_LDO1V2_LP_TB_X_DUT_ICONST_75A_0_)
                    current_state = STARTUP;
            end
            STARTUP: begin
                // condition: SREF_LDO1V2_LP_TB.X_DUT.IBIAS_SNK_25nA_[1] == 0
                if (V(SREF_LDO1V2_LP_TB_X_DUT_IBIAS_SNK_25nA__1_) < VTH_SREF_LDO1V2_LP_TB_X_DUT_IBIAS_SNK_25nA__1_)
                    current_state = REGULATION_2;
            end
            REGULATION_2: begin
                // condition: SREF_LDO1V2_LP_TB.ICONST_75A[0] == 0
                // condition: SREF_LDO1V2_LP_TB.X_DUT.ICONST_75A[0] == 0
                if (V(SREF_LDO1V2_LP_TB_ICONST_75A_0_) < VTH_SREF_LDO1V2_LP_TB_ICONST_75A_0_ && V(SREF_LDO1V2_LP_TB_X_DUT_ICONST_75A_0_) < VTH_SREF_LDO1V2_LP_TB_X_DUT_ICONST_75A_0_)
                    current_state = REGULATION;
            end
            REGULATION_3: begin
                // condition: SREF_LDO1V2_LP_TB.X_DUT.IBIAS_SNK_25nA_[0] == 1
                // condition: SREF_LDO1V2_LP_TB.X_DUT.IBIAS_SNK_25nA_[1] == 1
                if (V(SREF_LDO1V2_LP_TB_X_DUT_IBIAS_SNK_25nA__0_) > VTH_SREF_LDO1V2_LP_TB_X_DUT_IBIAS_SNK_25nA__0_ && V(SREF_LDO1V2_LP_TB_X_DUT_IBIAS_SNK_25nA__1_) > VTH_SREF_LDO1V2_LP_TB_X_DUT_IBIAS_SNK_25nA__1_)
                    current_state = REGULATION_4;
            end
            REGULATION_4: begin
                // condition: SREF_LDO1V2_LP_TB.ICONST_75A[0] == 1
                // condition: SREF_LDO1V2_LP_TB.X_DUT.ICONST_75A[0] == 1
                if (V(SREF_LDO1V2_LP_TB_ICONST_75A_0_) > VTH_SREF_LDO1V2_LP_TB_ICONST_75A_0_ && V(SREF_LDO1V2_LP_TB_X_DUT_ICONST_75A_0_) > VTH_SREF_LDO1V2_LP_TB_X_DUT_ICONST_75A_0_)
                    current_state = OVERRIDE;
            end
            OVERRIDE: begin
                // condition: SREF_LDO1V2_LP_TB.X_DUT.IBIAS_SNK_25nA_[0] == 0
                // condition: SREF_LDO1V2_LP_TB.X_DUT.IBIAS_SNK_25nA_[1] == 0
                // condition: SREF_LDO1V2_LP_TB.X_DUT.IBIAS_SNK_25nA_[2] == 0
                if (V(SREF_LDO1V2_LP_TB_X_DUT_IBIAS_SNK_25nA__0_) < VTH_SREF_LDO1V2_LP_TB_X_DUT_IBIAS_SNK_25nA__0_ && V(SREF_LDO1V2_LP_TB_X_DUT_IBIAS_SNK_25nA__1_) < VTH_SREF_LDO1V2_LP_TB_X_DUT_IBIAS_SNK_25nA__1_ && V(SREF_LDO1V2_LP_TB_X_DUT_IBIAS_SNK_25nA__2_) < VTH_SREF_LDO1V2_LP_TB_X_DUT_IBIAS_SNK_25nA__2_)
                    current_state = REGULATION_2;
            end
        endcase

        V(EN_UVLO_1V2) <+ ((current_state == REGULATION) || (current_state == REGULATION_2) || (current_state == REGULATION_3) || (current_state == REGULATION_4)) ? 5.5 : 0.0;

    end  // analog begin

endmodule

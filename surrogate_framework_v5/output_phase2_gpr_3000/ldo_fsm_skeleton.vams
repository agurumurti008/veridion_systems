// Auto-generated Verilog-A FSM — LDO
// Generated by surrogate_framework FSMCodeGenerator

`include "disciplines.vams"
`include "constants.vams"

module ldo_fsm_model(
    VPWR, GND, floop_out, floop_in, EN_LDO, EN_UVLO_1V2, VPWR_SEL, PAD_VDD1V2_SEL, UVLO_GD_OR_OVERRIDE_MPOS, HIGH_POWER_MODE, SCAN_MODE_VSUPPLY, EN_SCAN_MODE_MPOS, FS_V_SUPPLY_TO_MOST_POS, SREF_ADD_LDO1V2_LOAD_MPOS, SREF_EN_ISENSE_LDO1V2_MPOS, SREF_LDO_ISNS_DIS_MPOS, IBIAS_SNK_25nA_0, IBIAS_SNK_25nA_1, IBIAS_SNK_25nA_2, ICONST_75A, VFB, VREF, AVSS, PBKG, FUN_DC, ISO, MOST_POS, VDD_1V2, VDD_1V2_EXT, V_SUPPLY
);

    input floop_in, IBIAS_SNK_25nA_0, IBIAS_SNK_25nA_1, IBIAS_SNK_25nA_2, ICONST_75A, VFB, VREF;
    output floop_out, EN_UVLO_1V2;
    inout VPWR, GND, AVSS, PBKG, FUN_DC, ISO, MOST_POS, VDD_1V2, VDD_1V2_EXT, V_SUPPLY;
    electrical VPWR, GND, floop_out, floop_in, EN_UVLO_1V2, IBIAS_SNK_25nA_0, IBIAS_SNK_25nA_1, IBIAS_SNK_25nA_2, ICONST_75A, VFB, VREF, AVSS, PBKG, FUN_DC, ISO, MOST_POS, VDD_1V2, VDD_1V2_EXT, V_SUPPLY;

    // Corner/meta parameters (equation inputs with
    // no physical pin — override per simulated corner)
    parameter real meta_corner_nn = 0.625993;
    parameter real meta_corner_ss = 0.240067;
    parameter real meta_corner_ww = 0.13394;
    parameter real meta_temp = -4.29365;
    parameter real meta_vsup_max = 5.04993;

    // Supply-sensitive logic pins (mixed-signal
    // boundary via attribute annotation, no V()
    // threshold needed — see _va_guard).
    input (* integer supplySensitivity = "V_SUPPLY"; integer groundSensitivity = "GND"; *) EN_LDO;
    logic EN_LDO;
    input (* integer supplySensitivity = "V_SUPPLY"; integer groundSensitivity = "GND"; *) VPWR_SEL;
    logic VPWR_SEL;
    input (* integer supplySensitivity = "V_SUPPLY"; integer groundSensitivity = "GND"; *) PAD_VDD1V2_SEL;
    logic PAD_VDD1V2_SEL;
    input (* integer supplySensitivity = "V_SUPPLY"; integer groundSensitivity = "GND"; *) UVLO_GD_OR_OVERRIDE_MPOS;
    logic UVLO_GD_OR_OVERRIDE_MPOS;
    input (* integer supplySensitivity = "V_SUPPLY"; integer groundSensitivity = "GND"; *) HIGH_POWER_MODE;
    logic HIGH_POWER_MODE;
    input (* integer supplySensitivity = "V_SUPPLY"; integer groundSensitivity = "GND"; *) SCAN_MODE_VSUPPLY;
    logic SCAN_MODE_VSUPPLY;
    input (* integer supplySensitivity = "V_SUPPLY"; integer groundSensitivity = "GND"; *) EN_SCAN_MODE_MPOS;
    logic EN_SCAN_MODE_MPOS;
    input (* integer supplySensitivity = "V_SUPPLY"; integer groundSensitivity = "GND"; *) FS_V_SUPPLY_TO_MOST_POS;
    logic FS_V_SUPPLY_TO_MOST_POS;
    input (* integer supplySensitivity = "V_SUPPLY"; integer groundSensitivity = "GND"; *) SREF_ADD_LDO1V2_LOAD_MPOS;
    logic SREF_ADD_LDO1V2_LOAD_MPOS;
    input (* integer supplySensitivity = "V_SUPPLY"; integer groundSensitivity = "GND"; *) SREF_EN_ISENSE_LDO1V2_MPOS;
    logic SREF_EN_ISENSE_LDO1V2_MPOS;
    input (* integer supplySensitivity = "V_SUPPLY"; integer groundSensitivity = "GND"; *) SREF_LDO_ISNS_DIS_MPOS;
    logic SREF_LDO_ISNS_DIS_MPOS;

    parameter integer DISABLED = 0;
    parameter integer REGULATION = 1;
    parameter integer REGULATION_2 = 2;
    parameter integer REGULATION_3 = 3;
    parameter integer REGULATION_4 = 4;
    parameter integer REGULATION_5 = 5;
    parameter integer DISABLED_2 = 6;
    parameter integer REGULATION_6 = 7;
    parameter integer REGULATION_7 = 8;
    parameter integer REGULATION_8 = 9;
    parameter integer REGULATION_9 = 10;
    parameter integer REGULATION_10 = 11;
    parameter integer REGULATION_11 = 12;
    parameter integer REGULATION_12 = 13;

    integer current_state;

    analog begin

        @(initial_step) begin
            current_state = 0;
        end

        // ── Pin operating-range self-checks ──
        if ((V(VPWR) < 4.5) || (V(VPWR) > 5.5))
            $strobe("[%m] VPWR out of range: %g (expected [4.5, 5.5] voltage)", V(VPWR));
        if ((V(GND) < -0.1) || (V(GND) > 0.1))
            $strobe("[%m] GND out of range: %g (expected [-0.1, 0.1] voltage)", V(GND));
        if ((I(IBIAS_SNK_25nA_0) < 0) || (I(IBIAS_SNK_25nA_0) > 3e-08))
            $strobe("[%m] IBIAS_SNK_25nA_0 out of range: %g (expected [0, 3e-08] current)", I(IBIAS_SNK_25nA_0));
        if ((I(IBIAS_SNK_25nA_1) < 0) || (I(IBIAS_SNK_25nA_1) > 3e-08))
            $strobe("[%m] IBIAS_SNK_25nA_1 out of range: %g (expected [0, 3e-08] current)", I(IBIAS_SNK_25nA_1));
        if ((I(IBIAS_SNK_25nA_2) < 0) || (I(IBIAS_SNK_25nA_2) > 3e-08))
            $strobe("[%m] IBIAS_SNK_25nA_2 out of range: %g (expected [0, 3e-08] current)", I(IBIAS_SNK_25nA_2));
        if ((I(ICONST_75A) < 0) || (I(ICONST_75A) > 0.9))
            $strobe("[%m] ICONST_75A out of range: %g (expected [0, 0.9] current)", I(ICONST_75A));
        if ((V(AVSS) < -0.1) || (V(AVSS) > 0.1))
            $strobe("[%m] AVSS out of range: %g (expected [-0.1, 0.1] voltage)", V(AVSS));
        if ((V(PBKG) < -0.1) || (V(PBKG) > 0.1))
            $strobe("[%m] PBKG out of range: %g (expected [-0.1, 0.1] voltage)", V(PBKG));
        if ((V(FUN_DC) < 4.5) || (V(FUN_DC) > 5.5))
            $strobe("[%m] FUN_DC out of range: %g (expected [4.5, 5.5] voltage)", V(FUN_DC));
        if ((V(ISO) < 4.5) || (V(ISO) > 5.5))
            $strobe("[%m] ISO out of range: %g (expected [4.5, 5.5] voltage)", V(ISO));
        if ((V(MOST_POS) < 4.5) || (V(MOST_POS) > 5.5))
            $strobe("[%m] MOST_POS out of range: %g (expected [4.5, 5.5] voltage)", V(MOST_POS));
        if ((V(VDD_1V2) < 1.1) || (V(VDD_1V2) > 1.3))
            $strobe("[%m] VDD_1V2 out of range: %g (expected [1.1, 1.3] voltage)", V(VDD_1V2));
        if ((V(VDD_1V2_EXT) < 1.1) || (V(VDD_1V2_EXT) > 1.3))
            $strobe("[%m] VDD_1V2_EXT out of range: %g (expected [1.1, 1.3] voltage)", V(VDD_1V2_EXT));
        if ((V(V_SUPPLY) < 4.5) || (V(V_SUPPLY) > 5.5))
            $strobe("[%m] V_SUPPLY out of range: %g (expected [4.5, 5.5] voltage)", V(V_SUPPLY));

        case (current_state)
            DISABLED: begin
                // condition: EN_LDO == 1
                if (EN_LDO)
                    current_state = REGULATION;
            end
            REGULATION: begin
                // condition: EN_LDO == 0
                // condition: HIGH_POWER_MODE == 1
                if (!EN_LDO && HIGH_POWER_MODE)
                    current_state = DISABLED_2;
                // condition: SREF_ADD_LDO1V2_LOAD_MPOS == 1
                // condition: VPWR_SEL == 0
                else if (SREF_ADD_LDO1V2_LOAD_MPOS && !VPWR_SEL)
                    current_state = REGULATION_11;
                // condition: EN_LDO == 0
                else if (!EN_LDO)
                    current_state = DISABLED;
                // condition: VPWR_SEL == 0
                else if (!VPWR_SEL)
                    current_state = REGULATION_2;
                // condition: HIGH_POWER_MODE == 1
                else if (HIGH_POWER_MODE)
                    current_state = REGULATION_5;
                // condition: SCAN_MODE_VSUPPLY == 1
                else if (SCAN_MODE_VSUPPLY)
                    current_state = REGULATION_6;
            end
            REGULATION_2: begin
                // condition: HIGH_POWER_MODE == 1
                // condition: VPWR_SEL == 1
                if (HIGH_POWER_MODE && VPWR_SEL)
                    current_state = REGULATION_5;
                // condition: VPWR_SEL == 1
                else if (VPWR_SEL)
                    current_state = REGULATION;
                // condition: HIGH_POWER_MODE == 1
                else if (HIGH_POWER_MODE)
                    current_state = REGULATION_3;
                // condition: SREF_ADD_LDO1V2_LOAD_MPOS == 1
                else if (SREF_ADD_LDO1V2_LOAD_MPOS)
                    current_state = REGULATION_11;
            end
            REGULATION_3: begin
                // condition: SREF_ADD_LDO1V2_LOAD_MPOS == 1
                if (SREF_ADD_LDO1V2_LOAD_MPOS)
                    current_state = REGULATION_4;
                // condition: VPWR_SEL == 1
                else if (VPWR_SEL)
                    current_state = REGULATION_5;
            end
            REGULATION_4: begin
                // condition: HIGH_POWER_MODE == 0
                // condition: SREF_ADD_LDO1V2_LOAD_MPOS == 0
                if (!HIGH_POWER_MODE && !SREF_ADD_LDO1V2_LOAD_MPOS)
                    current_state = REGULATION_2;
            end
            REGULATION_5: begin
                // condition: HIGH_POWER_MODE == 0
                if (!HIGH_POWER_MODE)
                    current_state = REGULATION;
            end
            DISABLED_2: begin
                // condition: EN_LDO == 1
                if (EN_LDO)
                    current_state = REGULATION_5;
            end
            REGULATION_6: begin
                // condition: EN_SCAN_MODE_MPOS == 1
                // condition: SCAN_MODE_VSUPPLY == 0
                if (EN_SCAN_MODE_MPOS && !SCAN_MODE_VSUPPLY)
                    current_state = REGULATION_7;
            end
            REGULATION_7: begin
                // condition: SCAN_MODE_VSUPPLY == 1
                if (SCAN_MODE_VSUPPLY)
                    current_state = REGULATION_8;
            end
            REGULATION_8: begin
                // condition: SREF_ADD_LDO1V2_LOAD_MPOS == 1
                if (SREF_ADD_LDO1V2_LOAD_MPOS)
                    current_state = REGULATION_9;
            end
            REGULATION_9: begin
                // condition: EN_SCAN_MODE_MPOS == 0
                // condition: SCAN_MODE_VSUPPLY == 0
                if (!EN_SCAN_MODE_MPOS && !SCAN_MODE_VSUPPLY)
                    current_state = REGULATION_10;
            end
            REGULATION_10: begin
                // condition: SREF_ADD_LDO1V2_LOAD_MPOS == 0
                if (!SREF_ADD_LDO1V2_LOAD_MPOS)
                    current_state = REGULATION;
            end
            REGULATION_11: begin
                // condition: EN_SCAN_MODE_MPOS == 1
                // condition: SCAN_MODE_VSUPPLY == 1
                if (EN_SCAN_MODE_MPOS && SCAN_MODE_VSUPPLY)
                    current_state = REGULATION_12;
            end
            REGULATION_12: begin
                // condition: EN_SCAN_MODE_MPOS == 0
                // condition: SCAN_MODE_VSUPPLY == 0
                // condition: SREF_ADD_LDO1V2_LOAD_MPOS == 0
                if (!EN_SCAN_MODE_MPOS && !SCAN_MODE_VSUPPLY && !SREF_ADD_LDO1V2_LOAD_MPOS)
                    current_state = REGULATION_2;
            end
        endcase

        // ── Fitted per-state output equations (Phase 2 modeling) ──
        case (current_state)
            DISABLED: begin
                I(FUN_DC, GND) <+ V(VREF) * -0.00021942465;  // FUN_DC_I
                V(VDD_1V2) <+ V(VREF) * (meta_corner_nn - V(VREF));
                I(VDD_1V2_EXT, GND) <+ -6.364355e-7 / exp(V(VPWR));  // VDD_1V2_EXT_I
                I(VPWR, GND) <+ V(VREF) * 0.041126497;  // VPWR_I
                I(V_SUPPLY, GND) <+ V(VREF) * 0.00022544723;  // V_SUPPLY_I
            end
            REGULATION: begin
                I(FUN_DC, GND) <+ (((meta_vsup_max * -1.023022) + (meta_vsup_max * 1.0230219)) * V(FUN_DC)) / -1.2538127;  // FUN_DC_I
                V(VDD_1V2) <+ (meta_corner_nn - ((V(V_SUPPLY) / meta_temp) + V(VDD_1V2_EXT))) - 0.1248706;
                I(VDD_1V2_EXT, GND) <+ meta_corner_ss * (V(VDD_1V2_EXT) * (0.1878143 ^ meta_vsup_max));  // VDD_1V2_EXT_I
                I(VPWR, GND) <+ 0.03181063 / exp(meta_corner_nn);  // VPWR_I
                I(V_SUPPLY, GND) <+ V(VDD_1V2_EXT) * 0.00025553588;  // V_SUPPLY_I
            end
            REGULATION_2: begin
                I(FUN_DC, GND) <+ 0.010260521 - ((meta_corner_nn * meta_temp) * 5.9347847e-5);  // FUN_DC_I
                V(VDD_1V2) <+ (V(VDD_1V2_EXT) / 1.3543456e-12) + meta_corner_nn;
                I(VDD_1V2_EXT, GND) <+ (meta_temp ^ meta_corner_ss) * 1.1903831e-9;  // VDD_1V2_EXT_I
                I(VPWR, GND) <+ (V(V_SUPPLY) - V(VPWR)) ^ V(VREF);  // VPWR_I
                I(V_SUPPLY, GND) <+ 0.00010063949 / exp(meta_corner_nn);  // V_SUPPLY_I
            end
            REGULATION_3: begin
                I(FUN_DC, GND) <+ (meta_corner_ss / meta_temp) - -0.11064038;  // FUN_DC_I
                V(VDD_1V2) <+ (meta_temp * 0.0033589804) + (0.7354823 ^ meta_corner_ss);
                I(VDD_1V2_EXT, GND) <+ ((meta_vsup_max - V(VPWR)) ^ 0.0058348337) * -8.2952283e-7;  // VDD_1V2_EXT_I
                I(VPWR, GND) <+ sqrt(sqrt(V(FUN_DC) - V(VPWR))) / exp(meta_corner_nn);  // VPWR_I
                I(V_SUPPLY, GND) <+ (V(V_SUPPLY) - V(VPWR)) * 0.044856936;  // V_SUPPLY_I
            end
            REGULATION_4: begin
                I(FUN_DC, GND) <+ (1.6288927 / meta_temp) + 0.086470686;  // FUN_DC_I
                V(VDD_1V2) <+ 0.6750668 ^ meta_corner_ss;
                I(VDD_1V2_EXT, GND) <+ meta_corner_nn * 2.0927114e-8;  // VDD_1V2_EXT_I
                I(VPWR, GND) <+ ((-0.7931885 ^ meta_corner_ww) / (meta_temp * V(FUN_DC))) * -0.0011562345;  // VPWR_I
                I(V_SUPPLY, GND) <+ exp(meta_temp * 0.21126595) * V(VDD_1V2_EXT);  // V_SUPPLY_I
            end
            REGULATION_5: begin
                I(FUN_DC, GND) <+ (meta_corner_ss * exp(V(VPWR))) * -3.349362e-8;  // FUN_DC_I
                V(VDD_1V2) <+ 17.734211 / meta_temp;
                I(VDD_1V2_EXT, GND) <+ (meta_temp * (1.5592729e-9 * meta_corner_ss)) - 4.0980222e-8;  // VDD_1V2_EXT_I
                I(VPWR, GND) <+ 0.13132995 / exp(meta_corner_nn);  // VPWR_I
                I(V_SUPPLY, GND) <+ exp(meta_corner_nn) * 5.3895974e-6;  // V_SUPPLY_I
            end
            DISABLED_2: begin
                I(FUN_DC, GND) <+ (-0.46269885 ^ meta_corner_nn) * (1.9374716e-5 / (V(V_SUPPLY) / meta_temp));  // FUN_DC_I
                V(VDD_1V2) <+ meta_corner_nn - 1.2501094;
                I(VDD_1V2_EXT, GND) <+ meta_temp * (meta_corner_ss * 6.5788965e-9);  // VDD_1V2_EXT_I
                I(VPWR, GND) <+ 0.059411358 / exp(meta_corner_nn);  // VPWR_I
                I(V_SUPPLY, GND) <+ (meta_corner_ss + V(V_SUPPLY)) * 3.786347e-5;  // V_SUPPLY_I
            end
            REGULATION_6: begin
                I(FUN_DC, GND) <+ (((3.8794441 ^ V(V_SUPPLY)) * -6.6813555e-9) + 9.786783e-6) * meta_corner_nn;  // FUN_DC_I
                V(VDD_1V2) <+ (meta_corner_nn * (V(VPWR) ^ 0.56206447)) + -1.4522996;
                I(VDD_1V2_EXT, GND) <+ (meta_temp ^ meta_corner_ss) * 3.5509453e-9;  // VDD_1V2_EXT_I
                I(VPWR, GND) <+ 0.028002143 / (meta_corner_nn + 1.0943004);  // VPWR_I
                I(V_SUPPLY, GND) <+ (exp(sqrt(exp(V(FUN_DC) ^ meta_corner_ss))) * meta_temp) * 1.2306385e-15;  // V_SUPPLY_I
            end
            REGULATION_7: begin
                I(FUN_DC, GND) <+ meta_corner_nn * (-6.5588174e-5 - (-0.00034985054 / meta_vsup_max));  // FUN_DC_I
                V(VDD_1V2) <+ ((meta_corner_nn * V(V_SUPPLY)) ^ 0.5561609) - 1.4656484;
                I(VDD_1V2_EXT, GND) <+ (meta_temp ^ meta_corner_ss) * 3.7002321e-9;  // VDD_1V2_EXT_I
                I(VPWR, GND) <+ 0.01810873 - (meta_temp * -0.00011692533);  // VPWR_I
                I(V_SUPPLY, GND) <+ meta_temp * (V(VDD_1V2_EXT) * (meta_corner_ss / exp(V(V_SUPPLY) / (V(VREF) * -0.4162371))));  // V_SUPPLY_I
            end
            REGULATION_8: begin
                I(FUN_DC, GND) <+ ((meta_corner_nn * 2.721065) ^ V(V_SUPPLY)) * ((2.1131052e-6 / meta_vsup_max) + -3.924735e-7);  // FUN_DC_I
                V(VDD_1V2) <+ ((meta_corner_nn * 0.47112486) * V(V_SUPPLY)) - 1.4851253;
                I(VDD_1V2_EXT, GND) <+ (meta_temp ^ meta_corner_ss) * 3.5985344e-9;  // VDD_1V2_EXT_I
                I(VPWR, GND) <+ (meta_corner_nn * -0.012240113) + 0.026069034;  // VPWR_I
                I(V_SUPPLY, GND) <+ V(VDD_1V2_EXT) * (meta_temp * (((V(FUN_DC) ^ meta_corner_ss) * V(VPWR)) ^ V(FUN_DC)));  // V_SUPPLY_I
            end
            REGULATION_9: begin
                I(FUN_DC, GND) <+ meta_corner_nn * ((V(V_SUPPLY) * -4.873445e-6) - -2.4617542e-5);  // FUN_DC_I
                V(VDD_1V2) <+ (meta_corner_nn * 2.3558204) - 1.4595085;
                I(VDD_1V2_EXT, GND) <+ ((meta_temp - -37.626545) ^ meta_corner_ss) * 2.8657816e-9;  // VDD_1V2_EXT_I
                I(VPWR, GND) <+ (0.023959162 - (meta_temp * (meta_corner_ss * -0.00018170338))) + (meta_corner_nn * -0.009569389);  // VPWR_I
                I(V_SUPPLY, GND) <+ (9.669508e-14 * (meta_temp * exp(meta_vsup_max))) * exp(meta_vsup_max ^ meta_corner_ss);  // V_SUPPLY_I
            end
            REGULATION_10: begin
                I(FUN_DC, GND) <+ 1.0075229e-6 / (V(V_SUPPLY) - ((meta_corner_ss * 0.17950268) * meta_temp));  // FUN_DC_I
                V(VDD_1V2) <+ log((meta_corner_nn + 1.2348759) - ((-45.265182 / meta_temp) ^ meta_corner_nn));
                I(VDD_1V2_EXT, GND) <+ ((meta_temp * 2.8660658e-9) + 1.16080074e-7) * meta_corner_ss;  // VDD_1V2_EXT_I
                I(VPWR, GND) <+ 0.015244789 - (((meta_temp * -6.907349e-5) - 0.003192626) / exp(meta_corner_nn - meta_corner_ss));  // VPWR_I
                I(V_SUPPLY, GND) <+ (meta_temp * (exp(log(V(VPWR)) ^ V(VPWR)) * V(VDD_1V2_EXT))) * meta_corner_ss;  // V_SUPPLY_I
            end
            REGULATION_11: begin
                I(FUN_DC, GND) <+ ((meta_corner_ss * meta_temp) * 7.709605e-5) + 0.011035271;  // FUN_DC_I
                V(VDD_1V2) <+ exp(meta_corner_nn + (6.3129 / meta_temp)) + -2.383977;
                I(VDD_1V2_EXT, GND) <+ meta_corner_ss * (1.8781276e-7 - (meta_temp * -3.5796812e-9));  // VDD_1V2_EXT_I
                I(VPWR, GND) <+ ((meta_temp * 8.5312466e-5) + 0.00505587) / exp(V(V_SUPPLY) ^ meta_corner_nn);  // VPWR_I
                I(V_SUPPLY, GND) <+ ((V(FUN_DC) + meta_corner_ss) * 3.6029058e-5) - 0.000108637265;  // V_SUPPLY_I
            end
            REGULATION_12: begin
                I(FUN_DC, GND) <+ 0.022221725 / sqrt((0.9911508 ^ meta_temp) + meta_corner_nn);  // FUN_DC_I
                V(VDD_1V2) <+ (sqrt(V(V_SUPPLY) + (91.38168 / meta_temp)) * meta_corner_nn) + -1.4729534;
                I(VDD_1V2_EXT, GND) <+ ((meta_temp * 2.904899e-9) + 1.1423748e-7) * meta_corner_ss;  // VDD_1V2_EXT_I
                I(VPWR, GND) <+ (exp(V(FUN_DC)) / meta_temp) * -1.4070043e-6;  // VPWR_I
                I(V_SUPPLY, GND) <+ (meta_temp * (exp(V(VPWR) ^ meta_corner_ss) * V(VDD_1V2_EXT))) / (0.09454076 ^ V(VPWR));  // V_SUPPLY_I
            end
            default: ;
        endcase

        V(EN_UVLO_1V2) <+ ((current_state == REGULATION) || (current_state == REGULATION_2) || (current_state == REGULATION_3) || (current_state == REGULATION_4) || (current_state == REGULATION_5) || (current_state == REGULATION_6) || (current_state == REGULATION_7) || (current_state == REGULATION_8) || (current_state == REGULATION_9) || (current_state == REGULATION_10) || (current_state == REGULATION_11) || (current_state == REGULATION_12)) ? 5.5 : 0.0;

    end  // analog begin

endmodule

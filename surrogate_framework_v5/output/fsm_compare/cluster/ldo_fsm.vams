// Auto-generated Verilog-A FSM — LDO
// Generated by surrogate_framework FSMCodeGenerator

`include "disciplines.vams"
`include "constants.vams"

module ldo_fsm_model(
    VPWR, GND, floop_out, floop_in, EN_LDO, EN_UVLO_1V2, VPWR_SEL, PAD_VDD1V2_SEL, UVLO_GD_OR_OVERRIDE_MPOS, HIGH_POWER_MODE, SCAN_MODE_VSUPPLY, EN_SCAN_MODE_MPOS, FS_V_SUPPLY_TO_MOST_POS, SREF_ADD_LDO1V2_LOAD_MPOS, SREF_EN_ISENSE_LDO1V2_MPOS, SREF_LDO_ISNS_DIS_MPOS, IBIAS_SNK_25nA_0, IBIAS_SNK_25nA_1, IBIAS_SNK_25nA_2, ICONST_75A, VFB, VREF, AVSS, PBKG, FUN_DC, ISO, MOST_POS, VDD_1V2, VDD_1V2_EXT, V_SUPPLY
);

    input floop_in, EN_LDO, VPWR_SEL, PAD_VDD1V2_SEL, UVLO_GD_OR_OVERRIDE_MPOS, HIGH_POWER_MODE, SCAN_MODE_VSUPPLY, EN_SCAN_MODE_MPOS, FS_V_SUPPLY_TO_MOST_POS, SREF_ADD_LDO1V2_LOAD_MPOS, SREF_EN_ISENSE_LDO1V2_MPOS, SREF_LDO_ISNS_DIS_MPOS, IBIAS_SNK_25nA_0, IBIAS_SNK_25nA_1, IBIAS_SNK_25nA_2, ICONST_75A, VFB, VREF;
    output floop_out, EN_UVLO_1V2;
    inout VPWR, GND, AVSS, PBKG, FUN_DC, ISO, MOST_POS, VDD_1V2, VDD_1V2_EXT, V_SUPPLY;
    electrical VPWR, GND, floop_out, floop_in, EN_LDO, EN_UVLO_1V2, VPWR_SEL, PAD_VDD1V2_SEL, UVLO_GD_OR_OVERRIDE_MPOS, HIGH_POWER_MODE, SCAN_MODE_VSUPPLY, EN_SCAN_MODE_MPOS, FS_V_SUPPLY_TO_MOST_POS, SREF_ADD_LDO1V2_LOAD_MPOS, SREF_EN_ISENSE_LDO1V2_MPOS, SREF_LDO_ISNS_DIS_MPOS, IBIAS_SNK_25nA_0, IBIAS_SNK_25nA_1, IBIAS_SNK_25nA_2, ICONST_75A, VFB, VREF, AVSS, PBKG, FUN_DC, ISO, MOST_POS, VDD_1V2, VDD_1V2_EXT, V_SUPPLY;

    parameter real VTH_HIGH_POWER_MODE = 2.75;  // logic threshold for HIGH_POWER_MODE
    parameter real VTH_SREF_ADD_LDO1V2_LOAD_MPOS = 2.75;  // logic threshold for SREF_ADD_LDO1V2_LOAD_MPOS
    parameter real VTH_VPWR_SEL = 2.75;  // logic threshold for VPWR_SEL
    parameter real VTH_EN_LDO = 2.75;  // logic threshold for EN_LDO
    parameter real VTH_EN_SCAN_MODE_MPOS = 2.75;  // logic threshold for EN_SCAN_MODE_MPOS
    parameter real VTH_SCAN_MODE_VSUPPLY = 2.75;  // logic threshold for SCAN_MODE_VSUPPLY

    parameter integer DISABLED = 0;
    parameter integer REGULATION = 1;
    parameter integer REGULATION_2 = 2;
    parameter integer REGULATION_3 = 3;
    parameter integer HIGH_POWER_MODE = 4;
    parameter integer SCAN_MODE = 5;
    parameter integer REGULATION_4 = 6;

    integer current_state;

    analog begin

        @(initial_step) begin
            current_state = 0;
        end

        case (current_state)
            DISABLED: begin
                // condition: HIGH_POWER_MODE > 0.5
                if (HIGH_POWER_MODE > 0.5)
                    current_state = HIGH_POWER_MODE;
                // condition: SREF_ADD_LDO1V2_LOAD_MPOS > 0.5
                else if (SREF_ADD_LDO1V2_LOAD_MPOS > 0.5)
                    current_state = REGULATION_4;
            end
            REGULATION: begin
                // condition: VPWR_SEL > 0.5
                if (V(VPWR_SEL) > 0.5)
                    current_state = REGULATION_2;
                // condition: SREF_ADD_LDO1V2_LOAD_MPOS > 0.5
                else if (SREF_ADD_LDO1V2_LOAD_MPOS > 0.5)
                    current_state = SCAN_MODE;
            end
            REGULATION_2: begin
                // condition: VPWR_SEL <= 0.5
                // condition: SREF_ADD_LDO1V2_LOAD_MPOS <= 0.5
                if (V(VPWR_SEL) <= 0.5 && V(SREF_ADD_LDO1V2_LOAD_MPOS) <= 0.5)
                    current_state = REGULATION;
                // condition: EN_LDO <= 0.5
                else if (EN_LDO <= 0.5)
                    current_state = REGULATION_3;
                // condition: SREF_ADD_LDO1V2_LOAD_MPOS > 0.5
                else if (SREF_ADD_LDO1V2_LOAD_MPOS > 0.5)
                    current_state = SCAN_MODE;
            end
            REGULATION_3: begin
                // condition: EN_LDO > 0.5
                if (EN_LDO > 0.5)
                    current_state = REGULATION_2;
            end
            HIGH_POWER_MODE: begin
                // condition: HIGH_POWER_MODE <= 0.5
                if (HIGH_POWER_MODE <= 0.5)
                    current_state = DISABLED;
            end
            SCAN_MODE: begin
                // condition: SREF_ADD_LDO1V2_LOAD_MPOS <= 0.5
                // condition: VPWR_SEL <= 0.5
                if (SREF_ADD_LDO1V2_LOAD_MPOS <= 0.5 && V(VPWR_SEL) <= 0.5)
                    current_state = REGULATION;
                // condition: SREF_ADD_LDO1V2_LOAD_MPOS <= 0.5
                // condition: VPWR_SEL > 0.5
                else if (SREF_ADD_LDO1V2_LOAD_MPOS <= 0.5 && V(VPWR_SEL) > 0.5)
                    current_state = REGULATION_2;
            end
            REGULATION_4: begin
                // condition: SREF_ADD_LDO1V2_LOAD_MPOS <= 0.5
                // condition: EN_SCAN_MODE_MPOS <= 0.5
                // condition: SCAN_MODE_VSUPPLY <= 0.5
                if (SREF_ADD_LDO1V2_LOAD_MPOS <= 0.5 && V(EN_SCAN_MODE_MPOS) <= 0.5 && V(SCAN_MODE_VSUPPLY) <= 0.5)
                    current_state = DISABLED;
            end
        endcase

        V(EN_UVLO_1V2) <+ ((current_state == REGULATION) || (current_state == REGULATION_2) || (current_state == REGULATION_3) || (current_state == REGULATION_4)) ? 5.5 : 0.0;

    end  // analog begin

endmodule

// Auto-generated Verilog-A — LDO Phase 1
// Generated by surrogate_framework Phase1SpecBasedGenerator

`include "disciplines.vams"
`include "constants.vams"

module ldo_model(
    VPWR, GND, floop_out, floop_in, EN_LDO, EN_UVLO_1V2, VPWR_SEL, PAD_VDD1V2_SEL, UVLO_GD_OR_OVERRIDE_MPOS, HIGH_POWER_MODE, SCAN_MODE_VSUPPLY, EN_SCAN_MODE_MPOS, FS_V_SUPPLY_TO_MOST_POS, SREF_ADD_LDO1V2_LOAD_MPOS, SREF_EN_ISENSE_LDO1V2_MPOS, SREF_LDO_ISNS_DIS_MPOS, IBIAS_SNK_25nA_0, IBIAS_SNK_25nA_1, IBIAS_SNK_25nA_2, ICONST_75A, VFB, VREF, AVSS, PBKG, FUN_DC, ISO, MOST_POS, VDD_1V2, VDD_1V2_EXT, V_SUPPLY
);

    electrical VPWR, GND, floop_out, floop_in, EN_LDO, EN_UVLO_1V2, VPWR_SEL, PAD_VDD1V2_SEL, UVLO_GD_OR_OVERRIDE_MPOS, HIGH_POWER_MODE, SCAN_MODE_VSUPPLY, EN_SCAN_MODE_MPOS, FS_V_SUPPLY_TO_MOST_POS, SREF_ADD_LDO1V2_LOAD_MPOS, SREF_EN_ISENSE_LDO1V2_MPOS, SREF_LDO_ISNS_DIS_MPOS, IBIAS_SNK_25nA_0, IBIAS_SNK_25nA_1, IBIAS_SNK_25nA_2, ICONST_75A, VFB, VREF, AVSS, PBKG, FUN_DC, ISO, MOST_POS, VDD_1V2, VDD_1V2_EXT, V_SUPPLY;
    input floop_in, EN_LDO, VPWR_SEL, PAD_VDD1V2_SEL, UVLO_GD_OR_OVERRIDE_MPOS, HIGH_POWER_MODE, SCAN_MODE_VSUPPLY, EN_SCAN_MODE_MPOS, FS_V_SUPPLY_TO_MOST_POS, SREF_ADD_LDO1V2_LOAD_MPOS, SREF_EN_ISENSE_LDO1V2_MPOS, SREF_LDO_ISNS_DIS_MPOS, IBIAS_SNK_25nA_0, IBIAS_SNK_25nA_1, IBIAS_SNK_25nA_2, ICONST_75A, VFB, VREF;
    output floop_out, EN_UVLO_1V2;
    inout VPWR, GND, AVSS, PBKG, FUN_DC, ISO, MOST_POS, VDD_1V2, VDD_1V2_EXT, V_SUPPLY;

    // Specification parameters
    parameter real Output_Voltage_nom = 1.2;  // [1.176, 1.224] V
    parameter real Dropout_Voltage_nom = 0.15;  // [0.0, 0.2] V
    parameter real Load_Regulation_nom = 12.5;  // [0.0, 25.1] mV/A
    parameter real Line_Regulation_nom = 1.5;  // [0.0, 3.0] mV/V
    parameter real PSRR_at_1kHz_nom = 80.0;  // [60.0, 100.0] dB
    parameter real PSRR_at_1MHz_nom = 40.0;  // [30.0, 60.0] dB
    parameter real Output_Noise_RMS_nom = 15.0;  // [0.0, 30.0] uVrms
    parameter real Transient_Undershoot_nom = 50.0;  // [0.0, 100.0] mV
    parameter real Transient_Settling_nom = 2.5;  // [0.0, 5.0] us
    parameter real Output_Impedance_10MHz_nom = 25.0;  // [0.0, 50.0] mOhm
    parameter real Quiescent_Current_nom = 0.05;  // [0.0, 0.08] mA
    parameter real Max_Load_Current_nom = 220.0;  // [200.0, 250.0] mA

    // Internal variables
    real vout_ideal, psrr_effect_1k, psrr_effect_1m, load_reg_drop;
    real vref;
    integer current_state;

    // FSM state parameters (from specKG.fsm_states)
    parameter integer DISABLED = 0;
    parameter integer UVLO = 1;
    parameter integer STARTUP = 2;
    parameter integer REGULATION = 3;
    parameter integer HIGH_POWER_MODE = 4;
    parameter integer SCAN_MODE = 5;
    parameter integer OVERRIDE = 6;
    parameter integer SHUTDOWN = 7;

    analog begin

        @(initial_step) begin
            current_state = 0;
            vref = 0.9;
        end

        // FSM transitions (hand-authored for the canonical LDO
        // states this coarse spec-only template models)
        case(current_state)
            DISABLED: begin
                if (V(EN_LDO) > 0.9) begin
                    @(cross(V(EN_LDO) - 0.9, +1))
                    current_state = STARTUP;
                end
            end
            STARTUP: begin
                if (V(floop_out) > 0.95 * Output_Voltage_nom) begin
                    @(cross(V(floop_out) - 0.95*Output_Voltage_nom, +1))
                    current_state = REGULATION;
                end
            end
        endcase

        // Ideal output from feedback equation: Vout = Vref*(1+Rf1/Rf2)
        vout_ideal = 1.2;  // = vref*(1+Rf1/Rf2)

        // PSRR effect: ripple suppression
        psrr_effect_1k = (V(VPWR) - 1.3500) / 10000.00;
        psrr_effect_1m = (V(VPWR) - 1.3500) / 100.00;

        // Load regulation drop
        load_reg_drop = I(floop_out,GND) * (12.500000 / 1.2000);

        // Output voltage
        case(current_state)
            DISABLED: V(floop_out,GND) <+ 0;
            STARTUP:  V(floop_out,GND) <+ vout_ideal * (1 - exp(-$abstime / 1e-6));
            REGULATION: begin
                V(floop_out,GND) <+ vout_ideal + psrr_effect_1k - load_reg_drop;
            end
            default:  V(floop_out,GND) <+ 0;
        endcase

    end  // analog begin

endmodule  // ldo_model

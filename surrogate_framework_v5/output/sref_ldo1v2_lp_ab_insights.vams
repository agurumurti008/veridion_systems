// Auto-generated A+B Verilog-A model — LDO (FSM layer: learned; analog core: LdoPmosTemplate)
// Generated by surrogate_framework ab_codegen
//
// Baseline parameter values inlined for corner TT_1p8V_27C.
// PVT: baseline parameters are exported as $table_model-compatible
// 3-D tables (P index, vdd, temp) from the LUT provider — see the
// companion .tbl files (emit_pvt_tables). Example per-parameter use:
//   Gm_ea_pvt = $table_model(p_idx, vdd, temp, "ldo_ab_Gm_ea.tbl", "1L,1L,1L");
// NOTE: the NN provider cannot deploy to Verilog-A (no NN inference
// in VA) — NN-provider deployment requires exporting its predictions
// through emit_pvt_tables to the same .tbl form.
//
// LIMITATIONS (Option-2 gap-report: model proceeds with these uncharacterized):
// LIMITATIONS: state STARTUP not characterized (no run enters it)
// LIMITATIONS: state DROPOUT not characterized (no run enters it)
// LIMITATIONS: state FAULT not characterized (no run enters it)
// LIMITATIONS: state SCAN not characterized (no run enters it)
// LIMITATIONS: transition DISABLED->STARTUP unverified
// LIMITATIONS: transition DROPOUT->REGULATION_HP unverified
// LIMITATIONS: transition DROPOUT->REGULATION_LP unverified
// LIMITATIONS: transition FAULT->DISABLED unverified
// LIMITATIONS: transition REGULATION_HP->DISABLED unverified
// LIMITATIONS: transition REGULATION_HP->DROPOUT unverified
// LIMITATIONS: transition REGULATION_HP->FAULT unverified
// LIMITATIONS: transition REGULATION_LP->DISABLED unverified
// LIMITATIONS: transition REGULATION_LP->DROPOUT unverified
// LIMITATIONS: transition REGULATION_LP->FAULT unverified
// LIMITATIONS: transition STARTUP->REGULATION_HP unverified
// LIMITATIONS: transition STARTUP->REGULATION_LP unverified
// LIMITATIONS: DISABLED dwell too short for steady-state fit
// LIMITATIONS: mux VPWR_SEL,VPWR,FUN_DC,ISO,MOST_POS,V_SUPPLY path not current-verified
//
// Load model — auto-detected internal loads (3.8 dummy-load):
//   SREF_ADD_LDO1V2_LOAD_MPOS: internal_load +26.0 uA on assertion

`include "disciplines.vams"
`include "constants.vams"

// ─── Supply-sensitive connect modules (logic pins, per spec-JSON
//     voltage domain). L2E/E2L conversion tracks the named domain
//     supply/ground nets, not a global default. ───
// domain V_SUPPLY/GND: logic range [0, 5.5] V (nominal 2.75 V) — from spec JSON voltage_range of:
//   pins: EN_LDO, EN_UVLO_1V2, VPWR_SEL, PAD_VDD1V2_SEL, UVLO_GD_OR_OVERRIDE_MPOS, HIGH_POWER_MODE, SCAN_MODE_VSUPPLY, EN_SCAN_MODE_MPOS, FS_V_SUPPLY_TO_MOST_POS, SREF_ADD_LDO1V2_LOAD_MPOS, SREF_EN_ISENSE_LDO1V2_MPOS, SREF_LDO_ISNS_DIS_MPOS
connectmodule ab_e2l_V_SUPPLY_5p5V(a, d);
    input a;  electrical a;   // analog side, V_SUPPLY-referenced
    output d; ddiscrete d;    // logic side
    parameter real vth = 2.75;  // midpoint of [0, 5.5] from spec JSON
    logic dval;
    assign d = dval;
    always @(above(V(a) - vth)) dval = 1;
    always @(above(vth - V(a))) dval = 0;
endconnectmodule
connectmodule ab_l2e_V_SUPPLY_5p5V(d, a);
    input d;  ddiscrete d;
    output a; electrical a;   // drives V(V_SUPPLY)/V(GND) levels
    analog V(a) <+ transition((d !== 0) ? V(V_SUPPLY, GND) : 0.0, 0, 1n, 1n);
endconnectmodule

module ldo_ab_model(
    VPWR, GND, floop_out, floop_in, EN_LDO, EN_UVLO_1V2, VPWR_SEL, PAD_VDD1V2_SEL, UVLO_GD_OR_OVERRIDE_MPOS, HIGH_POWER_MODE, SCAN_MODE_VSUPPLY, EN_SCAN_MODE_MPOS, FS_V_SUPPLY_TO_MOST_POS, SREF_ADD_LDO1V2_LOAD_MPOS, SREF_EN_ISENSE_LDO1V2_MPOS, SREF_LDO_ISNS_DIS_MPOS, IBIAS_SNK_25nA_0, IBIAS_SNK_25nA_1, IBIAS_SNK_25nA_2, ICONST_75A, VFB, VREF, AVSS, PBKG, FUN_DC, ISO, MOST_POS, VDD_1V2, VDD_1V2_EXT, V_SUPPLY
);

    input floop_in, EN_LDO, VPWR_SEL, PAD_VDD1V2_SEL, UVLO_GD_OR_OVERRIDE_MPOS, HIGH_POWER_MODE, SCAN_MODE_VSUPPLY, EN_SCAN_MODE_MPOS, FS_V_SUPPLY_TO_MOST_POS, SREF_ADD_LDO1V2_LOAD_MPOS, SREF_EN_ISENSE_LDO1V2_MPOS, SREF_LDO_ISNS_DIS_MPOS, IBIAS_SNK_25nA_0, IBIAS_SNK_25nA_1, IBIAS_SNK_25nA_2, ICONST_75A, VFB, VREF;
    output floop_out, EN_UVLO_1V2;
    inout VPWR, GND, AVSS, PBKG, FUN_DC, ISO, MOST_POS, VDD_1V2, VDD_1V2_EXT, V_SUPPLY;
    electrical VPWR, GND, floop_out, floop_in, EN_LDO, EN_UVLO_1V2, VPWR_SEL, PAD_VDD1V2_SEL, UVLO_GD_OR_OVERRIDE_MPOS, HIGH_POWER_MODE, SCAN_MODE_VSUPPLY, EN_SCAN_MODE_MPOS, FS_V_SUPPLY_TO_MOST_POS, SREF_ADD_LDO1V2_LOAD_MPOS, SREF_EN_ISENSE_LDO1V2_MPOS, SREF_LDO_ISNS_DIS_MPOS, IBIAS_SNK_25nA_0, IBIAS_SNK_25nA_1, IBIAS_SNK_25nA_2, ICONST_75A, VFB, VREF, AVSS, PBKG, FUN_DC, ISO, MOST_POS, VDD_1V2, VDD_1V2_EXT, V_SUPPLY;
    electrical n_vg, n_vc;  // EA output node, compensator node

    // Baseline template parameters @ TT_1p8V_27C (PVT via .tbl files)
    parameter real Gm_ea = 0.001;  // S
    parameter real I_ea_max = 0.0001;  // A
    parameter real R_ea = 2e+06;  // Ohm
    parameter real C_ea = 2e-12;  // F
    parameter real Rz = 100000;  // Ohm
    parameter real Cc = 3e-11;  // F
    parameter real Kp = 2;  // A/V^2
    parameter real Vth_p = 0.6;  // V
    parameter real lambda_p = 0.03;  // 1/V
    parameter real Cgd = 1e-11;  // F
    parameter real Cgs = 2e-11;  // F
    parameter real Rf1 = 100000;  // Ohm
    parameter real Rf2 = 300000;  // Ohm
    parameter real V_ref = 0.9;  // V
    parameter real C_out = 4.7e-06;  // F
    parameter real R_esr = 0.3;  // Ohm
    parameter real I_lim = 0.4;  // A
    parameter real I_q = 2e-05;  // A
    parameter real V_uvlo_r = 3.6;  // V
    parameter real V_uvlo_f = 3.4;  // V
    parameter real hp_gm_scale = 3;  // -
    parameter real hp_ilim_scale = 2;  // -
    parameter real lp_iq_scale = 0.25;  // -
    parameter real k_load = 1e-06;  // S

    // Logic thresholds per guard pin (midpoint of spec-JSON range)
    parameter real VTH_EN_LDO = 2.75;
    parameter real VTH_VPWR_SEL = 2.75;
    parameter real VTH_SREF_ADD_LDO1V2_LOAD_MPOS = 2.75;
    parameter real fsm_ts = 1e-07;  // FSM sampling bound for $bound_step

    parameter integer DISABLED = 0;
    parameter integer REGULATION = 1;
    parameter integer REGULATION_2 = 2;
    parameter integer REGULATION_3 = 3;

    integer current_state;
    integer supplies_ok;
    integer VPWR_ok;
    integer GND_ok;
    integer IBIAS_SNK_25nA_0_ok;
    integer IBIAS_SNK_25nA_1_ok;
    integer IBIAS_SNK_25nA_2_ok;
    integer ICONST_75A_ok;
    integer AVSS_ok;
    integer PBKG_ok;
    integer FUN_DC_ok;
    integer ISO_ok;
    integer MOST_POS_ok;
    integer VDD_1V2_ok;
    integer VDD_1V2_EXT_ok;
    integer V_SUPPLY_ok;
    integer EN_LDO_b;
    integer VPWR_SEL_b;
    integer SREF_ADD_LDO1V2_LOAD_MPOS_b;
    real Gm_ea_eff, I_ea_max_eff, I_lim_eff, I_q_eff;
    real v_fb, i_ea, i_comp, v_sg, vov, v_sd, i_sq, i_pass, en_gate;

    analog begin
        // FSM sampling: bound the solver timestep so state-register
        // updates are re-evaluated at least every fsm_ts (the
        // repo's corrected pattern; cross-event controls inside case
        // arms are illegal Verilog-A and are never emitted).
        $bound_step(fsm_ts);

        @(initial_step) begin
            current_state = DISABLED;
        end

        // ── Pin self-checks (windows from the spec JSON) ──
        VPWR_ok = ((V(VPWR, GND) >= 4.5) && (V(VPWR, GND) <= 5.5)) ? 1 : 0;  // VPWR.voltage_range
        GND_ok = ((V(GND, GND) >= -0.1) && (V(GND, GND) <= 0.1)) ? 1 : 0;  // GND.voltage_range
        IBIAS_SNK_25nA_0_ok = ((I(IBIAS_SNK_25nA_0) >= 0) && (I(IBIAS_SNK_25nA_0) <= 3e-08)) ? 1 : 0;  // IBIAS_SNK_25nA_0.current_range
        IBIAS_SNK_25nA_1_ok = ((I(IBIAS_SNK_25nA_1) >= 0) && (I(IBIAS_SNK_25nA_1) <= 3e-08)) ? 1 : 0;  // IBIAS_SNK_25nA_1.current_range
        IBIAS_SNK_25nA_2_ok = ((I(IBIAS_SNK_25nA_2) >= 0) && (I(IBIAS_SNK_25nA_2) <= 3e-08)) ? 1 : 0;  // IBIAS_SNK_25nA_2.current_range
        ICONST_75A_ok = ((I(ICONST_75A) >= 0) && (I(ICONST_75A) <= 0.9)) ? 1 : 0;  // ICONST_75A.current_range
        AVSS_ok = ((V(AVSS, GND) >= -0.1) && (V(AVSS, GND) <= 0.1)) ? 1 : 0;  // AVSS.voltage_range
        PBKG_ok = ((V(PBKG, GND) >= -0.1) && (V(PBKG, GND) <= 0.1)) ? 1 : 0;  // PBKG.voltage_range
        FUN_DC_ok = ((V(FUN_DC, GND) >= 4.5) && (V(FUN_DC, GND) <= 5.5)) ? 1 : 0;  // FUN_DC.voltage_range
        ISO_ok = ((V(ISO, GND) >= 4.5) && (V(ISO, GND) <= 5.5)) ? 1 : 0;  // ISO.voltage_range
        MOST_POS_ok = ((V(MOST_POS, GND) >= 4.5) && (V(MOST_POS, GND) <= 5.5)) ? 1 : 0;  // MOST_POS.voltage_range
        VDD_1V2_ok = ((V(VDD_1V2, GND) >= 1.1) && (V(VDD_1V2, GND) <= 1.3)) ? 1 : 0;  // VDD_1V2.voltage_range
        VDD_1V2_EXT_ok = ((V(VDD_1V2_EXT, GND) >= 1.1) && (V(VDD_1V2_EXT, GND) <= 1.3)) ? 1 : 0;  // VDD_1V2_EXT.voltage_range
        V_SUPPLY_ok = ((V(V_SUPPLY, GND) >= 4.5) && (V(V_SUPPLY, GND) <= 5.5)) ? 1 : 0;  // V_SUPPLY.voltage_range
        supplies_ok = VPWR_ok && GND_ok && IBIAS_SNK_25nA_0_ok && IBIAS_SNK_25nA_1_ok && IBIAS_SNK_25nA_2_ok && ICONST_75A_ok && AVSS_ok && PBKG_ok && FUN_DC_ok && ISO_ok && MOST_POS_ok && VDD_1V2_ok && VDD_1V2_EXT_ok && V_SUPPLY_ok;

        // ── Control-pin logic levels ──
        EN_LDO_b = (V(EN_LDO, GND) > VTH_EN_LDO) ? 1 : 0;
        VPWR_SEL_b = (V(VPWR_SEL, GND) > VTH_VPWR_SEL) ? 1 : 0;
        SREF_ADD_LDO1V2_LOAD_MPOS_b = (V(SREF_ADD_LDO1V2_LOAD_MPOS, GND) > VTH_SREF_ADD_LDO1V2_LOAD_MPOS) ? 1 : 0;

        // ── FSM: supplies_ok gate outranks every learned guard ──
        if (!supplies_ok)
            current_state = DISABLED;
        else case (current_state)
            DISABLED: begin
                // learned: DISABLED -> REGULATION (p=0.013)
                if ((EN_LDO_b == 1))
                    current_state = REGULATION;
            end
            REGULATION: begin
                // learned: REGULATION -> REGULATION_2 (p=0.000)
                if ((VPWR_SEL_b == 1))
                    current_state = REGULATION_2;
                // learned: REGULATION -> REGULATION_3 (p=0.000)
                else if ((SREF_ADD_LDO1V2_LOAD_MPOS_b == 1))
                    current_state = REGULATION_3;
            end
            REGULATION_2: begin
                // no learned outgoing transitions
            end
            REGULATION_3: begin
                // learned: REGULATION_3 -> REGULATION (p=0.004)
                if ((SREF_ADD_LDO1V2_LOAD_MPOS_b == 0))
                    current_state = REGULATION;
            end
        endcase

        // ── Per-state parameter overrides (fitted deltas) ──
        Gm_ea_eff = Gm_ea;
        I_ea_max_eff = I_ea_max;
        I_lim_eff = I_lim;
        I_q_eff = I_q * lp_iq_scale;
        case (current_state)
            DISABLED: begin
                I_q_eff = 3.04014e-06;  // 3.10 measured Iq (sigma 6.2e-06 A)
            end
            REGULATION: begin
                I_q_eff = 4.98085e-05;  // 3.10 measured Iq (sigma 2e-06 A)
            end
            REGULATION_2: begin
                I_q_eff = 3.00831e-05;  // 3.10 measured Iq (sigma 2e-05 A)
            end
            REGULATION_3: begin
                I_q_eff = 5.00035e-05;  // 3.10 measured Iq (sigma 5.7e-08 A)
            end
            default: ;
        endcase

        // ── Analog core (LdoPmosTemplate equations) ──
        en_gate = ((current_state != DISABLED) && supplies_ok && (V(EN_LDO, GND) > VTH_EN_LDO)) ? 1.0 : 0.0;
        v_fb = V(VDD_1V2, GND) * Rf2 / (Rf1 + Rf2);
        // inverting gate drive (negative feedback, PMOS pass)
        i_ea = en_gate * I_ea_max_eff * tanh(Gm_ea_eff * (v_fb - V_ref) / I_ea_max_eff);
        i_comp = (V(n_vg) - V(n_vc)) / Rz;
        I(n_vg) <+ (C_ea + Cgs) * ddt(V(n_vg));
        I(n_vg) <+ -i_ea + i_comp;
        I(n_vg) <+ (en_gate > 0.5) ? V(n_vg) / R_ea : (V(n_vg) - V(V_SUPPLY, GND)) / R_ea;
        I(n_vg) <+ -Cgs * ddt(V(V_SUPPLY, GND));
        I(n_vc) <+ Cc * ddt(V(n_vc) - V(VDD_1V2, GND));
        I(n_vc) <+ -i_comp;
        v_sg = V(V_SUPPLY, GND) - V(n_vg);
        vov  = v_sg - Vth_p;
        v_sd = V(V_SUPPLY, VDD_1V2);
        if ((vov > 0) && (v_sd > 0)) begin
            if (v_sd >= vov)
                i_sq = 0.5 * Kp * vov * vov * (1 + lambda_p * v_sd);
            else  // triode branch IS dropout
                i_sq = Kp * (vov * v_sd - 0.5 * v_sd * v_sd) * (1 + lambda_p * v_sd);
        end else
            i_sq = 0.0;
        i_pass = en_gate * I_lim_eff * tanh(i_sq / I_lim_eff);
        // both behaviors emitted: V(vout) regulation AND I(vin) draw
        I(V_SUPPLY, VDD_1V2) <+ i_pass;
        I(V_SUPPLY, GND)  <+ (en_gate > 0.5) ? I_q_eff : 0.05 * I_q_eff;
        I(VDD_1V2, GND) <+ V(VDD_1V2, GND) / (Rf1 + Rf2);
        I(VDD_1V2, GND) <+ k_load * V(VDD_1V2, GND);
        I(VDD_1V2, GND) <+ -Cgd * ddt(V(V_SUPPLY, GND) - V(n_vg));
        I(VDD_1V2, GND) <+ C_out * ddt(V(VDD_1V2, GND));
        // supplies_ok low -> held safe: pass device off (en_gate=0),
        // V(VDD_1V2) bleeds to the ground reference
        I(VDD_1V2, GND) <+ (supplies_ok ? 0.0 : V(VDD_1V2, GND) / 1k);
    end

endmodule  // ldo_ab_model

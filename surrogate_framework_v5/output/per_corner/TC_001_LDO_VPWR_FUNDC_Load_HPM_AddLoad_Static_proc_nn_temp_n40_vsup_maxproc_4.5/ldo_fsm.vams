// Auto-generated Verilog-A FSM — LDO
// Generated by surrogate_framework FSMCodeGenerator

`include "disciplines.vams"
`include "constants.vams"

module ldo_fsm_model(
    VPWR, GND, floop_out, floop_in, EN_LDO, EN_UVLO_1V2, VPWR_SEL, PAD_VDD1V2_SEL, UVLO_GD_OR_OVERRIDE_MPOS, HIGH_POWER_MODE, SCAN_MODE_VSUPPLY, EN_SCAN_MODE_MPOS, FS_V_SUPPLY_TO_MOST_POS, SREF_ADD_LDO1V2_LOAD_MPOS, SREF_EN_ISENSE_LDO1V2_MPOS, SREF_LDO_ISNS_DIS_MPOS, IBIAS_SNK_25nA_0, IBIAS_SNK_25nA_1, IBIAS_SNK_25nA_2, ICONST_75A, VFB, VREF, AVSS, PBKG, FUN_DC, ISO, MOST_POS, VDD_1V2, VDD_1V2_EXT, V_SUPPLY
);

    input floop_in, EN_LDO, VPWR_SEL, PAD_VDD1V2_SEL, UVLO_GD_OR_OVERRIDE_MPOS, HIGH_POWER_MODE, SCAN_MODE_VSUPPLY, EN_SCAN_MODE_MPOS, FS_V_SUPPLY_TO_MOST_POS, SREF_ADD_LDO1V2_LOAD_MPOS, SREF_EN_ISENSE_LDO1V2_MPOS, SREF_LDO_ISNS_DIS_MPOS, IBIAS_SNK_25nA_0, IBIAS_SNK_25nA_1, IBIAS_SNK_25nA_2, ICONST_75A, VFB, VREF;
    output floop_out, EN_UVLO_1V2;
    inout VPWR, GND, AVSS, PBKG, FUN_DC, ISO, MOST_POS, VDD_1V2, VDD_1V2_EXT, V_SUPPLY;
    electrical VPWR, GND, floop_out, floop_in, EN_LDO, EN_UVLO_1V2, VPWR_SEL, PAD_VDD1V2_SEL, UVLO_GD_OR_OVERRIDE_MPOS, HIGH_POWER_MODE, SCAN_MODE_VSUPPLY, EN_SCAN_MODE_MPOS, FS_V_SUPPLY_TO_MOST_POS, SREF_ADD_LDO1V2_LOAD_MPOS, SREF_EN_ISENSE_LDO1V2_MPOS, SREF_LDO_ISNS_DIS_MPOS, IBIAS_SNK_25nA_0, IBIAS_SNK_25nA_1, IBIAS_SNK_25nA_2, ICONST_75A, VFB, VREF, AVSS, PBKG, FUN_DC, ISO, MOST_POS, VDD_1V2, VDD_1V2_EXT, V_SUPPLY;

    parameter real VTH_EN_LDO = 2.75;  // logic threshold for EN_LDO
    parameter real VTH_HIGH_POWER_MODE = 2.75;  // logic threshold for HIGH_POWER_MODE
    parameter real VTH_VPWR_SEL = 2.75;  // logic threshold for VPWR_SEL

    parameter integer DISABLED = 0;
    parameter integer REGULATION = 1;
    parameter integer REGULATION_2 = 2;
    parameter integer REGULATION_3 = 3;
    parameter integer DISABLED_2 = 4;

    integer current_state;

    analog begin

        @(initial_step) begin
            current_state = 0;
        end

        case (current_state)
            DISABLED: begin
                // condition: EN_LDO == 1
                if (V(EN_LDO) > VTH_EN_LDO)
                    current_state = REGULATION;
            end
            REGULATION: begin
                // condition: EN_LDO == 0
                // condition: HIGH_POWER_MODE == 1
                if (V(EN_LDO) < VTH_EN_LDO && V(HIGH_POWER_MODE) > VTH_HIGH_POWER_MODE)
                    current_state = DISABLED_2;
                // condition: EN_LDO == 0
                else if (V(EN_LDO) < VTH_EN_LDO)
                    current_state = DISABLED;
                // condition: VPWR_SEL == 0
                else if (V(VPWR_SEL) < VTH_VPWR_SEL)
                    current_state = REGULATION_2;
                // condition: HIGH_POWER_MODE == 1
                else if (V(HIGH_POWER_MODE) > VTH_HIGH_POWER_MODE)
                    current_state = REGULATION_3;
            end
            REGULATION_2: begin
                // condition: VPWR_SEL == 1
                if (V(VPWR_SEL) > VTH_VPWR_SEL)
                    current_state = REGULATION;
            end
            REGULATION_3: begin
                // condition: HIGH_POWER_MODE == 0
                if (V(HIGH_POWER_MODE) < VTH_HIGH_POWER_MODE)
                    current_state = REGULATION;
            end
            DISABLED_2: begin
                // condition: EN_LDO == 1
                if (V(EN_LDO) > VTH_EN_LDO)
                    current_state = REGULATION_3;
            end
        endcase

        V(EN_UVLO_1V2) <+ ((current_state == REGULATION) || (current_state == REGULATION_2) || (current_state == REGULATION_3)) ? 5.5 : 0.0;

    end  // analog begin

endmodule

// Auto-generated Verilog-A FSM — LDO
// Generated by surrogate_framework FSMCodeGenerator

`include "disciplines.vams"
`include "constants.vams"

module ldo_fsm_model(
    VPWR, GND, floop_out, floop_in, EN_LDO, EN_UVLO_1V2, VPWR_SEL, PAD_VDD1V2_SEL, UVLO_GD_OR_OVERRIDE_MPOS, HIGH_POWER_MODE, SCAN_MODE_VSUPPLY, EN_SCAN_MODE_MPOS, FS_V_SUPPLY_TO_MOST_POS, SREF_ADD_LDO1V2_LOAD_MPOS, SREF_EN_ISENSE_LDO1V2_MPOS, SREF_LDO_ISNS_DIS_MPOS, IBIAS_SNK_25nA_0, IBIAS_SNK_25nA_1, IBIAS_SNK_25nA_2, ICONST_75A, VFB, VREF, AVSS, PBKG, FUN_DC, ISO, MOST_POS, VDD_1V2, VDD_1V2_EXT, V_SUPPLY, SREF_LDO1V2_LP_TB_ICONST_75A_0_, SREF_LDO1V2_LP_TB_X_DUT_ICONST_75A_0_
);

    input floop_in, EN_LDO, VPWR_SEL, PAD_VDD1V2_SEL, UVLO_GD_OR_OVERRIDE_MPOS, HIGH_POWER_MODE, SCAN_MODE_VSUPPLY, EN_SCAN_MODE_MPOS, FS_V_SUPPLY_TO_MOST_POS, SREF_ADD_LDO1V2_LOAD_MPOS, SREF_EN_ISENSE_LDO1V2_MPOS, SREF_LDO_ISNS_DIS_MPOS, IBIAS_SNK_25nA_0, IBIAS_SNK_25nA_1, IBIAS_SNK_25nA_2, ICONST_75A, VFB, VREF, SREF_LDO1V2_LP_TB_ICONST_75A_0_, SREF_LDO1V2_LP_TB_X_DUT_ICONST_75A_0_;
    output floop_out, EN_UVLO_1V2;
    inout VPWR, GND, AVSS, PBKG, FUN_DC, ISO, MOST_POS, VDD_1V2, VDD_1V2_EXT, V_SUPPLY;
    electrical VPWR, GND, floop_out, floop_in, EN_LDO, EN_UVLO_1V2, VPWR_SEL, PAD_VDD1V2_SEL, UVLO_GD_OR_OVERRIDE_MPOS, HIGH_POWER_MODE, SCAN_MODE_VSUPPLY, EN_SCAN_MODE_MPOS, FS_V_SUPPLY_TO_MOST_POS, SREF_ADD_LDO1V2_LOAD_MPOS, SREF_EN_ISENSE_LDO1V2_MPOS, SREF_LDO_ISNS_DIS_MPOS, IBIAS_SNK_25nA_0, IBIAS_SNK_25nA_1, IBIAS_SNK_25nA_2, ICONST_75A, VFB, VREF, AVSS, PBKG, FUN_DC, ISO, MOST_POS, VDD_1V2, VDD_1V2_EXT, V_SUPPLY, SREF_LDO1V2_LP_TB_ICONST_75A_0_, SREF_LDO1V2_LP_TB_X_DUT_ICONST_75A_0_;

    parameter real VTH_SREF_LDO1V2_LP_TB_ICONST_75A_0_ = 0.5;  // logic threshold for SREF_LDO1V2_LP_TB.ICONST_75A[0]
    parameter real VTH_MOST_POS = 5;  // logic threshold for MOST_POS
    parameter real VTH_VPWR = 5;  // logic threshold for VPWR
    parameter real VTH_SREF_LDO1V2_LP_TB_X_DUT_ICONST_75A_0_ = 0.5;  // logic threshold for SREF_LDO1V2_LP_TB.X_DUT.ICONST_75A[0]

    parameter integer DISABLED = 0;
    parameter integer REGULATION = 1;
    parameter integer STARTUP = 2;

    integer current_state;

    analog begin

        @(initial_step) begin
            current_state = 0;
        end

        case (current_state)
            DISABLED: begin
                // condition: MOST_POS == 1
                // condition: VPWR == 1
                if (V(MOST_POS) > VTH_MOST_POS && V(VPWR) > VTH_VPWR)
                    current_state = REGULATION;
            end
            REGULATION: begin
                // condition: SREF_LDO1V2_LP_TB.ICONST_75A[0] == 1
                // condition: SREF_LDO1V2_LP_TB.X_DUT.ICONST_75A[0] == 1
                if (V(SREF_LDO1V2_LP_TB_ICONST_75A_0_) > VTH_SREF_LDO1V2_LP_TB_ICONST_75A_0_ && V(SREF_LDO1V2_LP_TB_X_DUT_ICONST_75A_0_) > VTH_SREF_LDO1V2_LP_TB_X_DUT_ICONST_75A_0_)
                    current_state = STARTUP;
            end
            STARTUP: begin
                // condition: SREF_LDO1V2_LP_TB.ICONST_75A[0] == 0
                // condition: SREF_LDO1V2_LP_TB.X_DUT.ICONST_75A[0] == 0
                if (V(SREF_LDO1V2_LP_TB_ICONST_75A_0_) < VTH_SREF_LDO1V2_LP_TB_ICONST_75A_0_ && V(SREF_LDO1V2_LP_TB_X_DUT_ICONST_75A_0_) < VTH_SREF_LDO1V2_LP_TB_X_DUT_ICONST_75A_0_)
                    current_state = REGULATION;
            end
        endcase

        V(EN_UVLO_1V2) <+ ((current_state == REGULATION)) ? 5.5 : 0.0;

    end  // analog begin

endmodule

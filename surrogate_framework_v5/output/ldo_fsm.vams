// Auto-generated Verilog-A FSM — LDO
// Generated by surrogate_framework FSMCodeGenerator

`include "disciplines.vams"
`include "constants.vams"

module ldo_fsm_model(
    VPWR, GND, floop_out, floop_in, EN_LDO, EN_UVLO_1V2, VPWR_SEL, PAD_VDD1V2_SEL, UVLO_GD_OR_OVERRIDE_MPOS, HIGH_POWER_MODE, SCAN_MODE_VSUPPLY, EN_SCAN_MODE_MPOS, FS_V_SUPPLY_TO_MOST_POS, SREF_ADD_LDO1V2_LOAD_MPOS, SREF_EN_ISENSE_LDO1V2_MPOS, SREF_LDO_ISNS_DIS_MPOS, IBIAS_SNK_25nA_0, IBIAS_SNK_25nA_1, IBIAS_SNK_25nA_2, ICONST_75A, VFB, VREF, AVSS, PBKG, FUN_DC, ISO, MOST_POS, VDD_1V2, VDD_1V2_EXT, V_SUPPLY
);

    input floop_in, IBIAS_SNK_25nA_0, IBIAS_SNK_25nA_1, IBIAS_SNK_25nA_2, ICONST_75A, VFB, VREF;
    output floop_out, EN_UVLO_1V2;
    inout VPWR, GND, AVSS, PBKG, FUN_DC, ISO, MOST_POS, VDD_1V2, VDD_1V2_EXT, V_SUPPLY;
    electrical VPWR, GND, floop_out, floop_in, EN_UVLO_1V2, IBIAS_SNK_25nA_0, IBIAS_SNK_25nA_1, IBIAS_SNK_25nA_2, ICONST_75A, VFB, VREF, AVSS, PBKG, FUN_DC, ISO, MOST_POS, VDD_1V2, VDD_1V2_EXT, V_SUPPLY;

    // Supply-sensitive logic pins (mixed-signal
    // boundary via attribute annotation, no V()
    // threshold needed — see _va_guard).
    input (* integer supplySensitivity = "V_SUPPLY"; integer groundSensitivity = "GND"; *) EN_LDO;
    logic EN_LDO;
    input (* integer supplySensitivity = "V_SUPPLY"; integer groundSensitivity = "GND"; *) VPWR_SEL;
    logic VPWR_SEL;
    input (* integer supplySensitivity = "V_SUPPLY"; integer groundSensitivity = "GND"; *) PAD_VDD1V2_SEL;
    logic PAD_VDD1V2_SEL;
    input (* integer supplySensitivity = "V_SUPPLY"; integer groundSensitivity = "GND"; *) UVLO_GD_OR_OVERRIDE_MPOS;
    logic UVLO_GD_OR_OVERRIDE_MPOS;
    input (* integer supplySensitivity = "V_SUPPLY"; integer groundSensitivity = "GND"; *) HIGH_POWER_MODE;
    logic HIGH_POWER_MODE;
    input (* integer supplySensitivity = "V_SUPPLY"; integer groundSensitivity = "GND"; *) SCAN_MODE_VSUPPLY;
    logic SCAN_MODE_VSUPPLY;
    input (* integer supplySensitivity = "V_SUPPLY"; integer groundSensitivity = "GND"; *) EN_SCAN_MODE_MPOS;
    logic EN_SCAN_MODE_MPOS;
    input (* integer supplySensitivity = "V_SUPPLY"; integer groundSensitivity = "GND"; *) FS_V_SUPPLY_TO_MOST_POS;
    logic FS_V_SUPPLY_TO_MOST_POS;
    input (* integer supplySensitivity = "V_SUPPLY"; integer groundSensitivity = "GND"; *) SREF_ADD_LDO1V2_LOAD_MPOS;
    logic SREF_ADD_LDO1V2_LOAD_MPOS;
    input (* integer supplySensitivity = "V_SUPPLY"; integer groundSensitivity = "GND"; *) SREF_EN_ISENSE_LDO1V2_MPOS;
    logic SREF_EN_ISENSE_LDO1V2_MPOS;
    input (* integer supplySensitivity = "V_SUPPLY"; integer groundSensitivity = "GND"; *) SREF_LDO_ISNS_DIS_MPOS;
    logic SREF_LDO_ISNS_DIS_MPOS;

    parameter integer DISABLED = 0;
    parameter integer DISABLED_2 = 1;
    parameter integer REGULATION = 2;
    parameter integer REGULATION_2 = 3;
    parameter integer REGULATION_3 = 4;
    parameter integer REGULATION_4 = 5;
    parameter integer DISABLED_3 = 6;
    parameter integer REGULATION_5 = 7;
    parameter integer DISABLED_4 = 8;
    parameter integer DISABLED_5 = 9;
    parameter integer DISABLED_6 = 10;
    parameter integer REGULATION_6 = 11;
    parameter integer REGULATION_7 = 12;
    parameter integer DISABLED_7 = 13;
    parameter integer REGULATION_8 = 14;
    parameter integer REGULATION_9 = 15;
    parameter integer REGULATION_10 = 16;

    integer current_state;  // digital-domain FSM state

    analog begin

        @(initial_step) begin
            current_state = 0;
        end

        // ── Pin operating-range self-checks ──
        if ((V(VPWR) < 4.5) || (V(VPWR) > 5.5))
            $strobe("[%m] VPWR out of range: %g (expected [4.5, 5.5] voltage)", V(VPWR));
        if ((V(GND) < -0.1) || (V(GND) > 0.1))
            $strobe("[%m] GND out of range: %g (expected [-0.1, 0.1] voltage)", V(GND));
        if ((I(IBIAS_SNK_25nA_0) < 0) || (I(IBIAS_SNK_25nA_0) > 3e-08))
            $strobe("[%m] IBIAS_SNK_25nA_0 out of range: %g (expected [0, 3e-08] current)", I(IBIAS_SNK_25nA_0));
        if ((I(IBIAS_SNK_25nA_1) < 0) || (I(IBIAS_SNK_25nA_1) > 3e-08))
            $strobe("[%m] IBIAS_SNK_25nA_1 out of range: %g (expected [0, 3e-08] current)", I(IBIAS_SNK_25nA_1));
        if ((I(IBIAS_SNK_25nA_2) < 0) || (I(IBIAS_SNK_25nA_2) > 3e-08))
            $strobe("[%m] IBIAS_SNK_25nA_2 out of range: %g (expected [0, 3e-08] current)", I(IBIAS_SNK_25nA_2));
        if ((I(ICONST_75A) < 0) || (I(ICONST_75A) > 0.9))
            $strobe("[%m] ICONST_75A out of range: %g (expected [0, 0.9] current)", I(ICONST_75A));
        if ((V(AVSS) < -0.1) || (V(AVSS) > 0.1))
            $strobe("[%m] AVSS out of range: %g (expected [-0.1, 0.1] voltage)", V(AVSS));
        if ((V(PBKG) < -0.1) || (V(PBKG) > 0.1))
            $strobe("[%m] PBKG out of range: %g (expected [-0.1, 0.1] voltage)", V(PBKG));
        if ((V(FUN_DC) < 4.5) || (V(FUN_DC) > 5.5))
            $strobe("[%m] FUN_DC out of range: %g (expected [4.5, 5.5] voltage)", V(FUN_DC));
        if ((V(ISO) < 4.5) || (V(ISO) > 5.5))
            $strobe("[%m] ISO out of range: %g (expected [4.5, 5.5] voltage)", V(ISO));
        if ((V(MOST_POS) < 4.5) || (V(MOST_POS) > 5.5))
            $strobe("[%m] MOST_POS out of range: %g (expected [4.5, 5.5] voltage)", V(MOST_POS));
        if ((V(VDD_1V2) < 1.1) || (V(VDD_1V2) > 1.3))
            $strobe("[%m] VDD_1V2 out of range: %g (expected [1.1, 1.3] voltage)", V(VDD_1V2));
        if ((V(VDD_1V2_EXT) < 1.1) || (V(VDD_1V2_EXT) > 1.3))
            $strobe("[%m] VDD_1V2_EXT out of range: %g (expected [1.1, 1.3] voltage)", V(VDD_1V2_EXT));
        if ((V(V_SUPPLY) < 4.5) || (V(V_SUPPLY) > 5.5))
            $strobe("[%m] V_SUPPLY out of range: %g (expected [4.5, 5.5] voltage)", V(V_SUPPLY));

        // ── Digital-domain state-transition logic ──
        case (current_state)
            DISABLED: begin
                // condition: VPWR_SEL == 1
                if (VPWR_SEL)
                    current_state = DISABLED_2;
                // condition: EN_LDO == 1
                else if (EN_LDO)
                    current_state = REGULATION_2;
            end
            DISABLED_2: begin
                // condition: EN_LDO == 1
                // condition: EN_SCAN_MODE_MPOS == 1
                // condition: HIGH_POWER_MODE == 1
                // condition: PAD_VDD1V2_SEL == 1
                // condition: SCAN_MODE_VSUPPLY == 1
                // condition: SREF_ADD_LDO1V2_LOAD_MPOS == 1
                if (EN_LDO && EN_SCAN_MODE_MPOS && HIGH_POWER_MODE && PAD_VDD1V2_SEL && SCAN_MODE_VSUPPLY && SREF_ADD_LDO1V2_LOAD_MPOS)
                    current_state = REGULATION_10;
                // condition: EN_LDO == 1
                // condition: EN_SCAN_MODE_MPOS == 1
                // condition: HIGH_POWER_MODE == 1
                // condition: SCAN_MODE_VSUPPLY == 1
                else if (EN_LDO && EN_SCAN_MODE_MPOS && HIGH_POWER_MODE && SCAN_MODE_VSUPPLY)
                    current_state = REGULATION_9;
                // condition: EN_LDO == 1
                // condition: EN_SCAN_MODE_MPOS == 1
                // condition: SCAN_MODE_VSUPPLY == 1
                else if (EN_LDO && EN_SCAN_MODE_MPOS && SCAN_MODE_VSUPPLY)
                    current_state = REGULATION_4;
                // condition: EN_LDO == 1
                // condition: HIGH_POWER_MODE == 1
                // condition: SREF_ADD_LDO1V2_LOAD_MPOS == 1
                else if (EN_LDO && HIGH_POWER_MODE && SREF_ADD_LDO1V2_LOAD_MPOS)
                    current_state = REGULATION_7;
                // condition: EN_LDO == 1
                // condition: HIGH_POWER_MODE == 1
                // condition: PAD_VDD1V2_SEL == 1
                else if (EN_LDO && HIGH_POWER_MODE && PAD_VDD1V2_SEL)
                    current_state = REGULATION_8;
                // condition: EN_LDO == 1
                // condition: PAD_VDD1V2_SEL == 1
                else if (EN_LDO && PAD_VDD1V2_SEL)
                    current_state = REGULATION_5;
                // condition: PAD_VDD1V2_SEL == 1
                // condition: UVLO_GD_OR_OVERRIDE_MPOS == 1
                else if (PAD_VDD1V2_SEL && UVLO_GD_OR_OVERRIDE_MPOS)
                    current_state = DISABLED_5;
                // condition: EN_SCAN_MODE_MPOS == 1
                // condition: SCAN_MODE_VSUPPLY == 1
                else if (EN_SCAN_MODE_MPOS && SCAN_MODE_VSUPPLY)
                    current_state = DISABLED_6;
                // condition: EN_LDO == 1
                // condition: HIGH_POWER_MODE == 1
                else if (EN_LDO && HIGH_POWER_MODE)
                    current_state = REGULATION_6;
                // condition: EN_LDO == 1
                else if (EN_LDO)
                    current_state = REGULATION;
                // condition: PAD_VDD1V2_SEL == 1
                else if (PAD_VDD1V2_SEL)
                    current_state = DISABLED_4;
            end
            REGULATION: begin
                // condition: EN_SCAN_MODE_MPOS == 1
                // condition: SCAN_MODE_VSUPPLY == 1
                if (EN_SCAN_MODE_MPOS && SCAN_MODE_VSUPPLY)
                    current_state = REGULATION_4;
                // condition: EN_LDO == 0
                else if (!EN_LDO)
                    current_state = DISABLED_2;
                // condition: VPWR_SEL == 0
                else if (!VPWR_SEL)
                    current_state = REGULATION_2;
                // condition: SREF_ADD_LDO1V2_LOAD_MPOS == 1
                else if (SREF_ADD_LDO1V2_LOAD_MPOS)
                    current_state = REGULATION_3;
                // condition: PAD_VDD1V2_SEL == 1
                else if (PAD_VDD1V2_SEL)
                    current_state = REGULATION_5;
                // condition: HIGH_POWER_MODE == 1
                else if (HIGH_POWER_MODE)
                    current_state = REGULATION_6;
            end
            REGULATION_2: begin
                // condition: VPWR_SEL == 1
                if (VPWR_SEL)
                    current_state = REGULATION;
            end
            REGULATION_3: begin
                // condition: EN_LDO == 0
                if (!EN_LDO)
                    current_state = DISABLED_3;
            end
            REGULATION_4: begin
                // condition: EN_LDO == 0
                if (!EN_LDO)
                    current_state = DISABLED_6;
            end
            DISABLED_3: begin
                // condition: EN_LDO == 1
                // condition: SREF_ADD_LDO1V2_LOAD_MPOS == 0
                if (EN_LDO && !SREF_ADD_LDO1V2_LOAD_MPOS)
                    current_state = REGULATION;
                // condition: EN_LDO == 1
                else if (EN_LDO)
                    current_state = REGULATION_3;
            end
            REGULATION_5: begin
                // condition: EN_LDO == 0
                if (!EN_LDO)
                    current_state = DISABLED_4;
                // condition: PAD_VDD1V2_SEL == 0
                else if (!PAD_VDD1V2_SEL)
                    current_state = REGULATION;
            end
            DISABLED_4: begin
                // condition: PAD_VDD1V2_SEL == 0
                if (!PAD_VDD1V2_SEL)
                    current_state = DISABLED_2;
                // condition: UVLO_GD_OR_OVERRIDE_MPOS == 1
                else if (UVLO_GD_OR_OVERRIDE_MPOS)
                    current_state = DISABLED_5;
                // condition: EN_LDO == 1
                else if (EN_LDO)
                    current_state = REGULATION_5;
            end
            DISABLED_5: begin
                // condition: UVLO_GD_OR_OVERRIDE_MPOS == 0
                if (!UVLO_GD_OR_OVERRIDE_MPOS)
                    current_state = DISABLED_4;
            end
            DISABLED_6: begin
                // terminal state — no transitions
            end
            REGULATION_6: begin
                // condition: HIGH_POWER_MODE == 0
                if (!HIGH_POWER_MODE)
                    current_state = REGULATION;
                // condition: SREF_ADD_LDO1V2_LOAD_MPOS == 1
                else if (SREF_ADD_LDO1V2_LOAD_MPOS)
                    current_state = REGULATION_7;
            end
            REGULATION_7: begin
                // terminal state — no transitions
            end
            DISABLED_7: begin
                // condition: VPWR_SEL == 1
                if (VPWR_SEL)
                    current_state = DISABLED_3;
            end
            REGULATION_8: begin
                // terminal state — no transitions
            end
            REGULATION_9: begin
                // terminal state — no transitions
            end
            REGULATION_10: begin
                // terminal state — no transitions
            end
        endcase

        V(EN_UVLO_1V2) <+ ((current_state == REGULATION) || (current_state == REGULATION_2) || (current_state == REGULATION_3) || (current_state == REGULATION_4) || (current_state == REGULATION_5) || (current_state == REGULATION_6) || (current_state == REGULATION_7) || (current_state == REGULATION_8) || (current_state == REGULATION_9) || (current_state == REGULATION_10)) ? 5.5 : 0.0;

    end  // analog begin

endmodule
